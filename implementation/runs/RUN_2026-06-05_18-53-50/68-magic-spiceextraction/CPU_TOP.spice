* NGSPICE file created from CPU_TOP.ext - technology: ihp-sg13g2

* Black-box entry subcircuit for sg13g2_a22oi_1 abstract view
.subckt sg13g2_a22oi_1 Y A1 A2 B1 B2 VDD VSS
.ends

* Black-box entry subcircuit for sg13g2_nor2_1 abstract view
.subckt sg13g2_nor2_1 Y A B VDD VSS
.ends

* Black-box entry subcircuit for sg13g2_decap_8 abstract view
.subckt sg13g2_decap_8 VDD VSS
.ends

* Black-box entry subcircuit for sg13g2_a21oi_1 abstract view
.subckt sg13g2_a21oi_1 Y A1 A2 B1 VDD VSS
.ends

* Black-box entry subcircuit for sg13g2_nand4_1 abstract view
.subckt sg13g2_nand4_1 Y A B C D VDD VSS
.ends

* Black-box entry subcircuit for sg13g2_o21ai_1 abstract view
.subckt sg13g2_o21ai_1 Y A1 A2 B1 VDD VSS
.ends

* Black-box entry subcircuit for sg13g2_fill_1 abstract view
.subckt sg13g2_fill_1 VDD VSS
.ends

* Black-box entry subcircuit for sg13g2_decap_4 abstract view
.subckt sg13g2_decap_4 VDD VSS
.ends

* Black-box entry subcircuit for sg13g2_inv_1 abstract view
.subckt sg13g2_inv_1 Y A VDD VSS
.ends

* Black-box entry subcircuit for sg13g2_nand2b_1 abstract view
.subckt sg13g2_nand2b_1 Y A_N B VDD VSS
.ends

* Black-box entry subcircuit for sg13g2_xnor2_1 abstract view
.subckt sg13g2_xnor2_1 Y A B VDD VSS
.ends

* Black-box entry subcircuit for sg13g2_nor4_2 abstract view
.subckt sg13g2_nor4_2 Y A B C D VDD VSS
.ends

* Black-box entry subcircuit for sg13g2_nor2b_1 abstract view
.subckt sg13g2_nor2b_1 Y A B_N VDD VSS
.ends

* Black-box entry subcircuit for sg13g2_buf_1 abstract view
.subckt sg13g2_buf_1 X A VDD VSS
.ends

* Black-box entry subcircuit for sg13g2_nor3_1 abstract view
.subckt sg13g2_nor3_1 Y A B C VDD VSS
.ends

* Black-box entry subcircuit for sg13g2_dfrbpq_1 abstract view
.subckt sg13g2_dfrbpq_1 Q CLK D RESET_B VDD VSS
.ends

* Black-box entry subcircuit for sg13g2_mux2_1 abstract view
.subckt sg13g2_mux2_1 X A0 A1 S VDD VSS
.ends

* Black-box entry subcircuit for sg13g2_fill_2 abstract view
.subckt sg13g2_fill_2 VDD VSS
.ends

* Black-box entry subcircuit for sg13g2_nand2_1 abstract view
.subckt sg13g2_nand2_1 Y A B VDD VSS
.ends

* Black-box entry subcircuit for sg13g2_and3_1 abstract view
.subckt sg13g2_and3_1 X A B C VDD VSS
.ends

* Black-box entry subcircuit for sg13g2_and2_1 abstract view
.subckt sg13g2_and2_1 X A B VDD VSS
.ends

* Black-box entry subcircuit for sg13g2_and4_1 abstract view
.subckt sg13g2_and4_1 X A B C D VDD VSS
.ends

* Black-box entry subcircuit for sg13g2_nand3_1 abstract view
.subckt sg13g2_nand3_1 Y A B C VDD VSS
.ends

* Black-box entry subcircuit for sg13g2_dlygate4sd3_1 abstract view
.subckt sg13g2_dlygate4sd3_1 X A VDD VSS
.ends

* Black-box entry subcircuit for sg13g2_a21o_1 abstract view
.subckt sg13g2_a21o_1 X A1 A2 B1 VDD VSS
.ends

* Black-box entry subcircuit for sg13g2_a221oi_1 abstract view
.subckt sg13g2_a221oi_1 Y A1 A2 B1 B2 C1 VDD VSS
.ends

* Black-box entry subcircuit for sg13g2_xor2_1 abstract view
.subckt sg13g2_xor2_1 X A B VDD VSS
.ends

* Black-box entry subcircuit for sg13g2_nor3_2 abstract view
.subckt sg13g2_nor3_2 Y A B C VDD VSS
.ends

* Black-box entry subcircuit for sg13g2_nand3b_1 abstract view
.subckt sg13g2_nand3b_1 Y A_N B C VDD VSS
.ends

* Black-box entry subcircuit for sg13g2_or4_1 abstract view
.subckt sg13g2_or4_1 X A B C D VDD VSS
.ends

* Black-box entry subcircuit for sg13g2_or2_1 abstract view
.subckt sg13g2_or2_1 X A B VDD VSS
.ends

* Black-box entry subcircuit for sg13g2_nor4_1 abstract view
.subckt sg13g2_nor4_1 Y A B C D VDD VSS
.ends

* Black-box entry subcircuit for sg13g2_or3_1 abstract view
.subckt sg13g2_or3_1 X A B C VDD VSS
.ends

* Black-box entry subcircuit for sg13g2_buf_4 abstract view
.subckt sg13g2_buf_4 X A VDD VSS
.ends

* Black-box entry subcircuit for sg13g2_buf_8 abstract view
.subckt sg13g2_buf_8 X A VDD VSS
.ends

* Black-box entry subcircuit for sg13g2_inv_8 abstract view
.subckt sg13g2_inv_8 Y A VDD VSS
.ends

* Black-box entry subcircuit for sg13g2_inv_2 abstract view
.subckt sg13g2_inv_2 Y A VDD VSS
.ends

* Black-box entry subcircuit for sg13g2_a21oi_2 abstract view
.subckt sg13g2_a21oi_2 Y A1 A2 B1 VDD VSS
.ends

* Black-box entry subcircuit for sg13g2_buf_2 abstract view
.subckt sg13g2_buf_2 X A VDD VSS
.ends

* Black-box entry subcircuit for sg13g2_buf_16 abstract view
.subckt sg13g2_buf_16 X A VDD VSS
.ends

* Black-box entry subcircuit for sg13g2_inv_16 abstract view
.subckt sg13g2_inv_16 Y A VDD VSS
.ends

* Black-box entry subcircuit for sg13g2_inv_4 abstract view
.subckt sg13g2_inv_4 Y A VDD VSS
.ends

* Black-box entry subcircuit for sg13g2_nand2b_2 abstract view
.subckt sg13g2_nand2b_2 Y A_N B VDD VSS
.ends

.subckt CPU_TOP VGND VPWR clk dmem_addr[0] dmem_addr[10] dmem_addr[11] dmem_addr[12]
+ dmem_addr[13] dmem_addr[14] dmem_addr[15] dmem_addr[16] dmem_addr[17] dmem_addr[18]
+ dmem_addr[19] dmem_addr[1] dmem_addr[20] dmem_addr[21] dmem_addr[22] dmem_addr[23]
+ dmem_addr[24] dmem_addr[25] dmem_addr[26] dmem_addr[27] dmem_addr[28] dmem_addr[29]
+ dmem_addr[2] dmem_addr[30] dmem_addr[31] dmem_addr[3] dmem_addr[4] dmem_addr[5]
+ dmem_addr[6] dmem_addr[7] dmem_addr[8] dmem_addr[9] dmem_rd dmem_rdata[0] dmem_rdata[10]
+ dmem_rdata[11] dmem_rdata[12] dmem_rdata[13] dmem_rdata[14] dmem_rdata[15] dmem_rdata[16]
+ dmem_rdata[17] dmem_rdata[18] dmem_rdata[19] dmem_rdata[1] dmem_rdata[20] dmem_rdata[21]
+ dmem_rdata[22] dmem_rdata[23] dmem_rdata[24] dmem_rdata[25] dmem_rdata[26] dmem_rdata[27]
+ dmem_rdata[28] dmem_rdata[29] dmem_rdata[2] dmem_rdata[30] dmem_rdata[31] dmem_rdata[3]
+ dmem_rdata[4] dmem_rdata[5] dmem_rdata[6] dmem_rdata[7] dmem_rdata[8] dmem_rdata[9]
+ dmem_wdata[0] dmem_wdata[10] dmem_wdata[11] dmem_wdata[12] dmem_wdata[13] dmem_wdata[14]
+ dmem_wdata[15] dmem_wdata[16] dmem_wdata[17] dmem_wdata[18] dmem_wdata[19] dmem_wdata[1]
+ dmem_wdata[20] dmem_wdata[21] dmem_wdata[22] dmem_wdata[23] dmem_wdata[24] dmem_wdata[25]
+ dmem_wdata[26] dmem_wdata[27] dmem_wdata[28] dmem_wdata[29] dmem_wdata[2] dmem_wdata[30]
+ dmem_wdata[31] dmem_wdata[3] dmem_wdata[4] dmem_wdata[5] dmem_wdata[6] dmem_wdata[7]
+ dmem_wdata[8] dmem_wdata[9] dmem_wr imem_addr[0] imem_addr[10] imem_addr[11] imem_addr[12]
+ imem_addr[13] imem_addr[14] imem_addr[15] imem_addr[16] imem_addr[17] imem_addr[18]
+ imem_addr[19] imem_addr[1] imem_addr[20] imem_addr[21] imem_addr[22] imem_addr[23]
+ imem_addr[24] imem_addr[25] imem_addr[26] imem_addr[27] imem_addr[28] imem_addr[29]
+ imem_addr[2] imem_addr[30] imem_addr[31] imem_addr[3] imem_addr[4] imem_addr[5]
+ imem_addr[6] imem_addr[7] imem_addr[8] imem_addr[9] imem_data[0] imem_data[10] imem_data[11]
+ imem_data[12] imem_data[13] imem_data[14] imem_data[15] imem_data[16] imem_data[17]
+ imem_data[18] imem_data[19] imem_data[1] imem_data[20] imem_data[21] imem_data[22]
+ imem_data[23] imem_data[24] imem_data[25] imem_data[26] imem_data[27] imem_data[28]
+ imem_data[29] imem_data[2] imem_data[30] imem_data[31] imem_data[3] imem_data[4]
+ imem_data[5] imem_data[6] imem_data[7] imem_data[8] imem_data[9] io_addr[0] io_addr[1]
+ io_addr[2] io_addr[3] io_addr[4] io_addr[5] io_addr[6] io_addr[7] io_rd io_rdata[0]
+ io_rdata[10] io_rdata[11] io_rdata[12] io_rdata[13] io_rdata[14] io_rdata[15] io_rdata[16]
+ io_rdata[17] io_rdata[18] io_rdata[19] io_rdata[1] io_rdata[20] io_rdata[21] io_rdata[22]
+ io_rdata[23] io_rdata[24] io_rdata[25] io_rdata[26] io_rdata[27] io_rdata[28] io_rdata[29]
+ io_rdata[2] io_rdata[30] io_rdata[31] io_rdata[3] io_rdata[4] io_rdata[5] io_rdata[6]
+ io_rdata[7] io_rdata[8] io_rdata[9] io_wdata[0] io_wdata[10] io_wdata[11] io_wdata[12]
+ io_wdata[13] io_wdata[14] io_wdata[15] io_wdata[16] io_wdata[17] io_wdata[18] io_wdata[19]
+ io_wdata[1] io_wdata[20] io_wdata[21] io_wdata[22] io_wdata[23] io_wdata[24] io_wdata[25]
+ io_wdata[26] io_wdata[27] io_wdata[28] io_wdata[29] io_wdata[2] io_wdata[30] io_wdata[31]
+ io_wdata[3] io_wdata[4] io_wdata[5] io_wdata[6] io_wdata[7] io_wdata[8] io_wdata[9]
+ io_wr rst
X_3155_ _4346_/A _2588_/Y _3246_/A2 _3153_/X _3154_/Y VPWR VGND sg13g2_a22oi_1
X_3086_ _3087_/B _3239_/A _3086_/B VPWR VGND sg13g2_nor2_1
XFILLER_50_420 VPWR VGND sg13g2_decap_8
X_3988_ _3988_/Y _4615_/A1 _3064_/A _4059_/A2 VPWR VGND sg13g2_a21oi_1
XFILLER_10_328 VPWR VGND sg13g2_decap_8
XFILLER_22_177 VPWR VGND sg13g2_decap_8
X_2939_ _2939_/Y _2939_/A _2939_/B _2939_/C _2939_/D VPWR VGND sg13g2_nand4_1
X_4609_ _4609_/Y _5457_/A _4608_/C _5458_/A VPWR VGND sg13g2_o21ai_1
XFILLER_7_7 VPWR VGND sg13g2_decap_8
XFILLER_73_545 VPWR VGND sg13g2_decap_8
XFILLER_73_578 VPWR VGND sg13g2_decap_8
XFILLER_60_217 VPWR VGND sg13g2_decap_8
XFILLER_13_122 VPWR VGND sg13g2_decap_8
XFILLER_14_634 VPWR VGND sg13g2_fill_1
XFILLER_41_442 VPWR VGND sg13g2_decap_8
XFILLER_13_155 VPWR VGND sg13g2_fill_1
XFILLER_41_497 VPWR VGND sg13g2_decap_8
XFILLER_5_376 VPWR VGND sg13g2_decap_8
XFILLER_49_553 VPWR VGND sg13g2_decap_8
XFILLER_24_409 VPWR VGND sg13g2_decap_4
XFILLER_64_567 VPWR VGND sg13g2_decap_8
XFILLER_51_228 VPWR VGND sg13g2_decap_8
X_4960_ _4960_/Y _5001_/A VPWR VGND sg13g2_inv_1
XFILLER_32_442 VPWR VGND sg13g2_decap_4
X_4891_ _4892_/C _4890_/B _4905_/A VPWR VGND sg13g2_nand2b_1
X_3911_ _3911_/Y _3916_/B _3910_/Y _3823_/A VPWR VGND sg13g2_a21oi_1
X_3842_ _3842_/Y _4452_/A _3874_/A VPWR VGND sg13g2_xnor2_1
X_3773_ _4158_/B _3773_/A _3773_/B _4438_/A _3773_/D VPWR VGND sg13g2_nor4_2
X_2724_ _2724_/Y _2724_/A _2710_/B VPWR VGND sg13g2_nor2b_1
XFILLER_8_181 VPWR VGND sg13g2_decap_4
XFILLER_8_170 VPWR VGND sg13g2_fill_1
XFILLER_66_0 VPWR VGND sg13g2_decap_8
X_5443_ _5443_/X _5443_/A VPWR VGND sg13g2_buf_1
X_2655_ _2655_/Y _4489_/B _2659_/B _4520_/A VPWR VGND sg13g2_nor3_1
X_5374_ _5374_/Q _5424_/CLK _5374_/D _5114_/Y VPWR VGND sg13g2_dfrbpq_1
X_4325_ _5321_/D _3908_/X hold798/X _4329_/S VPWR VGND sg13g2_mux2_1
X_2586_ _2586_/Y _2586_/A VPWR VGND sg13g2_inv_1
XFILLER_59_306 VPWR VGND sg13g2_decap_4
X_4256_ _5376_/D _2546_/Y _4258_/S _4255_/Y VPWR VGND sg13g2_o21ai_1
X_4187_ _4187_/Y _4457_/B _4162_/B _4186_/Y VPWR VGND sg13g2_o21ai_1
X_3207_ _3208_/B _4435_/B _3238_/A VPWR VGND sg13g2_xnor2_1
XFILLER_67_361 VPWR VGND sg13g2_fill_2
XFILLER_55_501 VPWR VGND sg13g2_decap_8
XFILLER_27_214 VPWR VGND sg13g2_decap_8
X_3138_ _3138_/Y _3139_/B _3138_/B VPWR VGND sg13g2_nand2_1
XFILLER_55_512 VPWR VGND sg13g2_fill_1
XFILLER_27_247 VPWR VGND sg13g2_decap_8
XFILLER_55_545 VPWR VGND sg13g2_decap_8
XFILLER_42_217 VPWR VGND sg13g2_decap_8
X_3069_ _3069_/Y _3069_/A _4517_/S VPWR VGND sg13g2_nor2_1
XFILLER_70_515 VPWR VGND sg13g2_decap_8
XFILLER_35_291 VPWR VGND sg13g2_decap_8
XFILLER_23_442 VPWR VGND sg13g2_decap_8
XFILLER_77_136 VPWR VGND sg13g2_decap_8
XFILLER_77_169 VPWR VGND sg13g2_decap_8
XFILLER_18_225 VPWR VGND sg13g2_decap_4
XFILLER_37_40 VPWR VGND sg13g2_fill_1
XFILLER_58_372 VPWR VGND sg13g2_decap_8
XFILLER_61_504 VPWR VGND sg13g2_decap_8
XFILLER_61_548 VPWR VGND sg13g2_fill_1
XFILLER_14_442 VPWR VGND sg13g2_decap_8
XFILLER_14_453 VPWR VGND sg13g2_fill_1
XFILLER_14_497 VPWR VGND sg13g2_decap_4
XFILLER_41_272 VPWR VGND sg13g2_fill_1
XFILLER_41_283 VPWR VGND sg13g2_decap_8
XFILLER_38_4 VPWR VGND sg13g2_fill_2
X_5090_ _5090_/Y _5129_/A VPWR VGND sg13g2_inv_1
X_4110_ _4111_/C _4112_/A _4110_/B _4133_/B VPWR VGND sg13g2_and3_1
X_4041_ _4041_/X _4041_/A _4041_/B VPWR VGND sg13g2_and2_1
XFILLER_68_147 VPWR VGND sg13g2_decap_8
XFILLER_37_523 VPWR VGND sg13g2_fill_1
XFILLER_37_545 VPWR VGND sg13g2_decap_8
XFILLER_64_320 VPWR VGND sg13g2_fill_1
XFILLER_52_504 VPWR VGND sg13g2_decap_8
XFILLER_52_526 VPWR VGND sg13g2_fill_1
XFILLER_64_386 VPWR VGND sg13g2_fill_1
X_4943_ _4943_/Y _4951_/A VPWR VGND sg13g2_inv_1
X_4874_ _5219_/D _4878_/A _4872_/Y _4873_/Y VPWR VGND sg13g2_a21oi_1
XFILLER_60_581 VPWR VGND sg13g2_decap_8
XFILLER_32_294 VPWR VGND sg13g2_fill_2
X_3825_ _3826_/B _4445_/C _3825_/B VPWR VGND sg13g2_xnor2_1
X_3756_ _3757_/D _3756_/A _4450_/B _4019_/B VPWR VGND sg13g2_nor3_1
X_2707_ _2708_/D _5371_/Q _3003_/A2 _3363_/B1 _5275_/Q VPWR VGND sg13g2_a22oi_1
X_5426_ _5426_/Q _5426_/CLK _5426_/D _5166_/Y VPWR VGND sg13g2_dfrbpq_1
X_3687_ _3691_/A _5387_/Q _3687_/B VPWR VGND sg13g2_nand2_1
Xoutput220 io_wdata[30] _5466_/X VPWR VGND sg13g2_buf_1
X_2638_ _4521_/B _2956_/B _4523_/A VPWR VGND sg13g2_nor2b_1
X_5357_ _5357_/Q _5421_/CLK _5357_/D _5097_/Y VPWR VGND sg13g2_dfrbpq_1
X_2569_ _2569_/Y _4318_/A VPWR VGND sg13g2_inv_1
X_5288_ _5288_/Q clkload8/A _5288_/D _5028_/Y VPWR VGND sg13g2_dfrbpq_1
X_4308_ _5336_/D _3136_/Y hold802/X _4312_/S VPWR VGND sg13g2_mux2_1
XFILLER_59_136 VPWR VGND sg13g2_decap_8
X_4239_ _5390_/D hold673/X _3796_/Y _4249_/B VPWR VGND sg13g2_mux2_1
XFILLER_28_501 VPWR VGND sg13g2_decap_4
XFILLER_74_139 VPWR VGND sg13g2_fill_1
XFILLER_74_117 VPWR VGND sg13g2_fill_1
XFILLER_74_106 VPWR VGND sg13g2_decap_8
XFILLER_55_320 VPWR VGND sg13g2_fill_1
XFILLER_43_559 VPWR VGND sg13g2_decap_8
XFILLER_23_261 VPWR VGND sg13g2_decap_8
XFILLER_11_478 VPWR VGND sg13g2_decap_8
XFILLER_23_86 VPWR VGND sg13g2_fill_2
Xfanout480 _4208_/A _4048_/A VPWR VGND sg13g2_buf_1
Xfanout491 _3210_/A _2668_/X VPWR VGND sg13g2_buf_1
XFILLER_65_128 VPWR VGND sg13g2_decap_8
XFILLER_74_651 VPWR VGND sg13g2_fill_1
XFILLER_74_640 VPWR VGND sg13g2_decap_8
XFILLER_0_46 VPWR VGND sg13g2_decap_8
XFILLER_34_515 VPWR VGND sg13g2_decap_8
XFILLER_34_526 VPWR VGND sg13g2_fill_2
XFILLER_61_334 VPWR VGND sg13g2_fill_1
XFILLER_61_367 VPWR VGND sg13g2_fill_1
XFILLER_61_356 VPWR VGND sg13g2_decap_8
XFILLER_14_283 VPWR VGND sg13g2_decap_4
X_4590_ _4590_/Y _5453_/A _4590_/B VPWR VGND sg13g2_xnor2_1
X_3610_ _3611_/D _5383_/Q _3676_/A2 _2714_/B VPWR VGND sg13g2_a21oi_1
X_3541_ _3541_/Y _4116_/B _3569_/B VPWR VGND sg13g2_nor2_1
XFILLER_6_471 VPWR VGND sg13g2_decap_8
X_3472_ _4048_/B _3574_/A _3472_/B VPWR VGND sg13g2_xnor2_1
X_5211_ _5211_/Q _5216_/CLK _5211_/D _4951_/Y VPWR VGND sg13g2_dfrbpq_1
X_5142_ _5142_/Y _5142_/A VPWR VGND sg13g2_inv_1
XFILLER_29_0 VPWR VGND sg13g2_decap_8
XFILLER_69_467 VPWR VGND sg13g2_fill_2
XFILLER_57_607 VPWR VGND sg13g2_fill_1
X_5073_ _5073_/Y _5175_/A VPWR VGND sg13g2_inv_1
XFILLER_56_128 VPWR VGND sg13g2_fill_2
X_4024_ _4025_/C _4024_/A _4024_/B VPWR VGND sg13g2_nand2_1
XFILLER_25_526 VPWR VGND sg13g2_decap_8
XFILLER_25_537 VPWR VGND sg13g2_fill_2
XFILLER_33_570 VPWR VGND sg13g2_fill_2
X_4926_ _4926_/Y _5153_/A VPWR VGND sg13g2_inv_1
XFILLER_20_242 VPWR VGND sg13g2_decap_8
X_4857_ _4876_/C _4857_/A _4858_/B VPWR VGND sg13g2_nor2_1
X_3808_ _3810_/C _4446_/A _3785_/C _3782_/B VPWR VGND sg13g2_a21oi_1
X_4788_ _4791_/B _4788_/A _4788_/B VPWR VGND sg13g2_xnor2_1
X_3739_ _3739_/X _3739_/A _3868_/A _3739_/C _3739_/D VPWR VGND sg13g2_and4_1
X_5409_ _5409_/Q clkload7/A _5409_/D _5149_/Y VPWR VGND sg13g2_dfrbpq_1
XFILLER_16_526 VPWR VGND sg13g2_fill_2
XFILLER_16_548 VPWR VGND sg13g2_fill_1
XFILLER_70_120 VPWR VGND sg13g2_decap_8
XFILLER_43_367 VPWR VGND sg13g2_decap_8
XFILLER_24_581 VPWR VGND sg13g2_decap_8
XFILLER_11_242 VPWR VGND sg13g2_decap_4
XFILLER_11_275 VPWR VGND sg13g2_decap_8
XFILLER_7_202 VPWR VGND sg13g2_decap_8
XFILLER_39_618 VPWR VGND sg13g2_decap_8
XFILLER_59_93 VPWR VGND sg13g2_decap_8
XFILLER_39_629 VPWR VGND sg13g2_decap_4
XFILLER_19_386 VPWR VGND sg13g2_decap_8
XFILLER_34_312 VPWR VGND sg13g2_decap_8
XFILLER_46_194 VPWR VGND sg13g2_fill_2
XFILLER_34_389 VPWR VGND sg13g2_decap_4
X_2972_ _3232_/C _2986_/A _2974_/B _2974_/C VPWR VGND sg13g2_nand3_1
XFILLER_15_592 VPWR VGND sg13g2_fill_2
X_4711_ _4725_/A _4712_/A _4717_/B VPWR VGND sg13g2_nand2_1
XFILLER_61_197 VPWR VGND sg13g2_decap_8
X_4642_ _4642_/X _4641_/B _4641_/Y _4642_/S VPWR VGND sg13g2_mux2_1
Xhold703 hold703/X _5345_/Q VPWR VGND sg13g2_dlygate4sd3_1
X_4573_ _4573_/Y _2573_/A _4559_/B _5449_/A _4580_/B VPWR VGND sg13g2_a22oi_1
Xhold714 hold714/X _5318_/Q VPWR VGND sg13g2_dlygate4sd3_1
Xhold725 hold725/X _5187_/Q VPWR VGND sg13g2_dlygate4sd3_1
Xhold736 hold736/X _5253_/Q VPWR VGND sg13g2_dlygate4sd3_1
X_3524_ _4087_/A _4096_/B _3566_/B VPWR VGND sg13g2_xnor2_1
Xhold747 hold747/X _5285_/Q VPWR VGND sg13g2_dlygate4sd3_1
Xhold769 hold769/X _5280_/Q VPWR VGND sg13g2_dlygate4sd3_1
Xhold758 hold758/X _5386_/Q VPWR VGND sg13g2_dlygate4sd3_1
X_3455_ _3455_/Y _3489_/A VPWR VGND sg13g2_inv_1
XFILLER_6_290 VPWR VGND sg13g2_decap_8
XFILLER_69_220 VPWR VGND sg13g2_decap_8
X_3386_ _3386_/Y _3386_/A _3386_/B VPWR VGND sg13g2_nor2_1
X_5125_ _5125_/Y _5125_/A VPWR VGND sg13g2_inv_1
XFILLER_57_415 VPWR VGND sg13g2_decap_8
X_5056_ _5056_/Y _5154_/A VPWR VGND sg13g2_inv_1
XFILLER_57_459 VPWR VGND sg13g2_decap_8
X_4007_ _4008_/D _4462_/A _3997_/B _4003_/Y VPWR VGND sg13g2_a21oi_1
XFILLER_72_429 VPWR VGND sg13g2_decap_8
XFILLER_25_301 VPWR VGND sg13g2_decap_8
XFILLER_65_470 VPWR VGND sg13g2_decap_8
XFILLER_25_356 VPWR VGND sg13g2_decap_8
XFILLER_80_451 VPWR VGND sg13g2_fill_2
XFILLER_13_529 VPWR VGND sg13g2_decap_8
XFILLER_40_304 VPWR VGND sg13g2_fill_2
XFILLER_40_315 VPWR VGND sg13g2_decap_8
X_4909_ _4909_/X _4904_/Y _4907_/Y _4908_/Y VPWR VGND sg13g2_a21o_1
XFILLER_21_562 VPWR VGND sg13g2_fill_1
XFILLER_21_584 VPWR VGND sg13g2_decap_8
XFILLER_4_227 VPWR VGND sg13g2_fill_2
XFILLER_29_96 VPWR VGND sg13g2_decap_4
XFILLER_28_150 VPWR VGND sg13g2_decap_4
XFILLER_44_632 VPWR VGND sg13g2_fill_1
XFILLER_56_470 VPWR VGND sg13g2_decap_8
XFILLER_43_175 VPWR VGND sg13g2_fill_1
XFILLER_6_23 VPWR VGND sg13g2_fill_2
XFILLER_8_599 VPWR VGND sg13g2_decap_8
XFILLER_6_56 VPWR VGND sg13g2_decap_8
X_3240_ _3241_/C _4139_/A1 _3225_/B _3239_/B _3120_/A _3239_/Y VPWR VGND sg13g2_a221oi_1
X_3171_ _3171_/Y _4436_/A _3171_/B VPWR VGND sg13g2_xnor2_1
XFILLER_54_407 VPWR VGND sg13g2_decap_4
XFILLER_19_161 VPWR VGND sg13g2_decap_8
XFILLER_81_226 VPWR VGND sg13g2_fill_1
XFILLER_34_142 VPWR VGND sg13g2_decap_8
XFILLER_50_602 VPWR VGND sg13g2_decap_8
XFILLER_22_337 VPWR VGND sg13g2_decap_8
XFILLER_62_495 VPWR VGND sg13g2_fill_2
X_2955_ _4185_/A _4489_/B _2955_/B _3000_/C VPWR VGND sg13g2_nand3_1
XFILLER_30_370 VPWR VGND sg13g2_decap_8
X_2886_ _2886_/Y _4524_/A _3403_/S VPWR VGND sg13g2_nor2_1
X_4625_ _4627_/A _4638_/A _5462_/A _4630_/C VPWR VGND sg13g2_o21ai_1
X_4556_ _4556_/X _4712_/A _5446_/A _4556_/S VPWR VGND sg13g2_mux2_1
X_3507_ _3714_/A _3507_/A _3507_/B VPWR VGND sg13g2_xor2_1
XFILLER_1_208 VPWR VGND sg13g2_fill_2
X_4487_ _4487_/Y _2667_/A _4521_/C VPWR VGND sg13g2_nand2b_1
X_3438_ _3440_/A _5254_/Q _3685_/B _3637_/B _5186_/Q VPWR VGND sg13g2_a22oi_1
X_3369_ _3369_/Y _5177_/Q _2841_/B _3369_/B1 _5405_/Q _3368_/Y VPWR VGND sg13g2_a221oi_1
X_5108_ _5108_/Y _5172_/A VPWR VGND sg13g2_inv_1
XFILLER_57_212 VPWR VGND sg13g2_fill_1
X_5039_ _5039_/Y _5166_/A VPWR VGND sg13g2_inv_1
XFILLER_53_451 VPWR VGND sg13g2_decap_4
XFILLER_15_21 VPWR VGND sg13g2_fill_2
XFILLER_25_175 VPWR VGND sg13g2_fill_2
XFILLER_9_308 VPWR VGND sg13g2_decap_8
XFILLER_31_42 VPWR VGND sg13g2_fill_2
XFILLER_48_223 VPWR VGND sg13g2_decap_8
XFILLER_48_234 VPWR VGND sg13g2_fill_1
XFILLER_76_532 VPWR VGND sg13g2_decap_8
XFILLER_48_267 VPWR VGND sg13g2_fill_1
XFILLER_76_576 VPWR VGND sg13g2_decap_8
XFILLER_56_83 VPWR VGND sg13g2_decap_8
XFILLER_44_440 VPWR VGND sg13g2_fill_2
XFILLER_44_473 VPWR VGND sg13g2_decap_8
XFILLER_16_186 VPWR VGND sg13g2_decap_8
XFILLER_71_292 VPWR VGND sg13g2_fill_1
XFILLER_31_156 VPWR VGND sg13g2_fill_2
X_2740_ _2741_/D _5434_/Q _2841_/B _2879_/A2 _5306_/Q VPWR VGND sg13g2_a22oi_1
XFILLER_8_330 VPWR VGND sg13g2_decap_8
X_2671_ _2671_/Y _3000_/B _2671_/B _2678_/C VPWR VGND sg13g2_nand3_1
XFILLER_8_341 VPWR VGND sg13g2_fill_2
X_4410_ _5247_/D _4335_/A hold842/X _4410_/S VPWR VGND sg13g2_mux2_1
XFILLER_68_4 VPWR VGND sg13g2_fill_2
X_5390_ _5390_/Q clkload2/A _5390_/D _5130_/Y VPWR VGND sg13g2_dfrbpq_1
X_4341_ _4341_/Y _4341_/A _4351_/B VPWR VGND sg13g2_nand2_1
Xfanout309 _4449_/A _3514_/Y VPWR VGND sg13g2_buf_1
X_4272_ _5365_/D hold702/X _3198_/Y _4273_/S VPWR VGND sg13g2_mux2_1
X_3223_ _4351_/A _3222_/B _3221_/Y _3222_/Y VPWR VGND sg13g2_o21ai_1
XFILLER_11_0 VPWR VGND sg13g2_decap_8
X_3154_ _3154_/Y _2575_/A _3197_/A2 _3154_/B1 VPWR VGND sg13g2_a21oi_1
XFILLER_27_429 VPWR VGND sg13g2_decap_8
XFILLER_39_278 VPWR VGND sg13g2_fill_2
XFILLER_39_289 VPWR VGND sg13g2_fill_2
X_3085_ _3087_/A _3085_/A _3085_/B _3085_/C _3085_/D VPWR VGND sg13g2_nand4_1
XFILLER_67_598 VPWR VGND sg13g2_fill_2
XFILLER_35_451 VPWR VGND sg13g2_decap_8
XFILLER_35_495 VPWR VGND sg13g2_decap_8
XFILLER_10_307 VPWR VGND sg13g2_decap_8
X_3987_ _3987_/Y _2685_/B _4481_/C _3986_/Y VPWR VGND sg13g2_o21ai_1
X_2938_ _2939_/D _5239_/Q _2938_/B VPWR VGND sg13g2_nand2_1
X_2869_ _3289_/A _2869_/A _2869_/B VPWR VGND sg13g2_and2_1
X_4608_ _4614_/B _5458_/A _5457_/A _4608_/C VPWR VGND sg13g2_nor3_2
XFILLER_2_528 VPWR VGND sg13g2_decap_4
X_4539_ _4542_/B _5441_/A _4539_/B VPWR VGND sg13g2_nor2_1
XFILLER_77_318 VPWR VGND sg13g2_fill_2
XFILLER_77_307 VPWR VGND sg13g2_decap_8
XFILLER_73_535 VPWR VGND sg13g2_fill_1
XFILLER_41_421 VPWR VGND sg13g2_decap_8
XFILLER_81_590 VPWR VGND sg13g2_decap_8
XFILLER_41_476 VPWR VGND sg13g2_decap_8
XFILLER_9_149 VPWR VGND sg13g2_decap_8
XFILLER_42_63 VPWR VGND sg13g2_decap_8
XFILLER_68_329 VPWR VGND sg13g2_decap_8
XFILLER_68_318 VPWR VGND sg13g2_fill_2
XFILLER_1_583 VPWR VGND sg13g2_decap_8
XFILLER_3_68 VPWR VGND sg13g2_decap_8
XFILLER_49_543 VPWR VGND sg13g2_fill_1
XFILLER_49_576 VPWR VGND sg13g2_fill_1
XFILLER_67_82 VPWR VGND sg13g2_decap_8
XFILLER_49_598 VPWR VGND sg13g2_decap_8
XFILLER_64_524 VPWR VGND sg13g2_fill_1
XFILLER_64_557 VPWR VGND sg13g2_decap_4
XFILLER_44_281 VPWR VGND sg13g2_fill_2
X_4890_ _4892_/B _4905_/A _4890_/B VPWR VGND sg13g2_nand2b_1
X_3910_ _3910_/Y _3945_/A _3945_/B _3615_/X VPWR VGND sg13g2_a21oi_1
XFILLER_20_605 VPWR VGND sg13g2_fill_1
X_3841_ _5420_/D hold765/X _3840_/Y _4013_/S VPWR VGND sg13g2_mux2_1
X_3772_ _3773_/D _4441_/B _4206_/B VPWR VGND sg13g2_nand2_1
X_2723_ _3443_/B _2754_/A _2723_/B _2723_/C VPWR VGND sg13g2_nand3b_1
X_5442_ _5442_/X _5442_/A VPWR VGND sg13g2_buf_1
X_2654_ _2656_/B _2659_/B _4520_/A VPWR VGND sg13g2_nor2_1
X_5373_ _5373_/Q _5426_/CLK _5373_/D _5113_/Y VPWR VGND sg13g2_dfrbpq_1
X_2585_ _2585_/Y _2585_/A VPWR VGND sg13g2_inv_1
X_4324_ _5322_/D _3890_/Y hold826/X _4329_/S VPWR VGND sg13g2_mux2_1
X_4255_ _4255_/Y _4255_/A _4258_/S VPWR VGND sg13g2_nand2_1
X_4186_ _4186_/Y _4211_/A2 _4441_/D _3233_/B _4162_/B _4185_/Y VPWR VGND sg13g2_a221oi_1
X_3206_ _3206_/Y _4159_/A _3206_/B VPWR VGND sg13g2_nor2_1
XFILLER_67_351 VPWR VGND sg13g2_fill_2
X_3137_ _5432_/D hold832/X _3136_/Y _4517_/S VPWR VGND sg13g2_mux2_1
XFILLER_67_373 VPWR VGND sg13g2_decap_8
X_3068_ _3068_/Y _4736_/A _4195_/A2 _3246_/A2 input4/X _3067_/Y VPWR VGND sg13g2_a221oi_1
XFILLER_11_649 VPWR VGND sg13g2_fill_2
XFILLER_12_11 VPWR VGND sg13g2_fill_2
XFILLER_12_33 VPWR VGND sg13g2_decap_8
XFILLER_12_77 VPWR VGND sg13g2_decap_4
XFILLER_2_358 VPWR VGND sg13g2_fill_2
XFILLER_77_115 VPWR VGND sg13g2_decap_8
XFILLER_58_351 VPWR VGND sg13g2_decap_8
XFILLER_37_85 VPWR VGND sg13g2_fill_1
XFILLER_46_557 VPWR VGND sg13g2_decap_8
XFILLER_46_568 VPWR VGND sg13g2_fill_1
XFILLER_33_218 VPWR VGND sg13g2_decap_8
XFILLER_37_96 VPWR VGND sg13g2_decap_8
XFILLER_46_579 VPWR VGND sg13g2_fill_2
XFILLER_73_398 VPWR VGND sg13g2_decap_8
XFILLER_54_590 VPWR VGND sg13g2_decap_8
XFILLER_53_51 VPWR VGND sg13g2_fill_1
XFILLER_14_476 VPWR VGND sg13g2_decap_8
XFILLER_53_95 VPWR VGND sg13g2_decap_8
XFILLER_5_130 VPWR VGND sg13g2_decap_8
XFILLER_5_152 VPWR VGND sg13g2_decap_4
XFILLER_52_7 VPWR VGND sg13g2_fill_1
XFILLER_5_174 VPWR VGND sg13g2_fill_2
XFILLER_68_126 VPWR VGND sg13g2_decap_8
X_4040_ _4040_/Y _4048_/B _4040_/B _4040_/C VPWR VGND sg13g2_nand3_1
XFILLER_37_502 VPWR VGND sg13g2_fill_1
XFILLER_49_373 VPWR VGND sg13g2_decap_8
XFILLER_64_354 VPWR VGND sg13g2_decap_8
XFILLER_45_590 VPWR VGND sg13g2_decap_8
XFILLER_52_538 VPWR VGND sg13g2_fill_2
X_4942_ _4942_/Y _4942_/A VPWR VGND sg13g2_inv_1
XFILLER_20_424 VPWR VGND sg13g2_decap_8
X_4873_ _4873_/Y _4878_/A _4873_/B VPWR VGND sg13g2_nor2_1
XFILLER_60_560 VPWR VGND sg13g2_decap_8
X_3824_ _3837_/B _3822_/Y _3823_/X _3829_/B VPWR VGND sg13g2_a21o_1
X_3755_ _4018_/B _4450_/B _4450_/C _4449_/A _3755_/D VPWR VGND sg13g2_or4_1
X_3686_ _3686_/Y _3686_/A _3686_/B _3686_/C _3686_/D VPWR VGND sg13g2_nand4_1
X_2706_ _2708_/C _5435_/Q _2800_/B _3361_/B _5403_/Q VPWR VGND sg13g2_a22oi_1
X_5425_ _5425_/Q _5425_/CLK _5425_/D _5165_/Y VPWR VGND sg13g2_dfrbpq_1
Xoutput210 io_wdata[21] _5457_/X VPWR VGND sg13g2_buf_1
X_2637_ _2637_/Y _2653_/B _2999_/A _2956_/C VPWR VGND sg13g2_nor3_1
Xoutput221 io_wdata[31] _5467_/X VPWR VGND sg13g2_buf_1
X_5356_ _5356_/Q clkload3/A _5356_/D _5096_/Y VPWR VGND sg13g2_dfrbpq_1
X_2568_ _4490_/A _2956_/B VPWR VGND sg13g2_inv_1
XFILLER_58_29 VPWR VGND sg13g2_decap_8
X_5287_ _5287_/Q clkload1/A _5287_/D _5027_/Y VPWR VGND sg13g2_dfrbpq_1
X_4307_ _5337_/D _4224_/A hold729/X _4317_/S VPWR VGND sg13g2_mux2_1
XFILLER_59_115 VPWR VGND sg13g2_decap_8
X_4238_ _4238_/Y _4360_/A _4360_/B _4238_/C VPWR VGND sg13g2_nor3_1
XFILLER_75_608 VPWR VGND sg13g2_decap_8
X_4169_ _4170_/B _3721_/B _4154_/Y _3726_/A VPWR VGND sg13g2_o21ai_1
XFILLER_55_332 VPWR VGND sg13g2_decap_4
XFILLER_15_218 VPWR VGND sg13g2_fill_2
XFILLER_43_538 VPWR VGND sg13g2_decap_8
XFILLER_55_387 VPWR VGND sg13g2_fill_2
XFILLER_23_240 VPWR VGND sg13g2_decap_4
XFILLER_70_379 VPWR VGND sg13g2_decap_8
XFILLER_11_424 VPWR VGND sg13g2_fill_2
XFILLER_7_428 VPWR VGND sg13g2_decap_8
XFILLER_3_645 VPWR VGND sg13g2_decap_8
XFILLER_48_73 VPWR VGND sg13g2_fill_1
Xfanout470 _2920_/A2 _3548_/A2 VPWR VGND sg13g2_buf_1
Xfanout481 _4048_/A _2673_/Y VPWR VGND sg13g2_buf_1
Xfanout492 _3679_/A _3704_/A VPWR VGND sg13g2_buf_1
XFILLER_65_107 VPWR VGND sg13g2_decap_4
XFILLER_0_25 VPWR VGND sg13g2_decap_8
XFILLER_19_557 VPWR VGND sg13g2_decap_8
XFILLER_58_181 VPWR VGND sg13g2_fill_1
XFILLER_73_140 VPWR VGND sg13g2_fill_2
XFILLER_61_313 VPWR VGND sg13g2_decap_8
XFILLER_9_89 VPWR VGND sg13g2_decap_4
XFILLER_80_82 VPWR VGND sg13g2_decap_4
X_3540_ _3569_/B _3542_/B _3542_/C VPWR VGND sg13g2_or2_1
XFILLER_50_4 VPWR VGND sg13g2_decap_8
X_5210_ _5210_/Q _5216_/CLK _5210_/D _4950_/Y VPWR VGND sg13g2_dfrbpq_1
X_3471_ _4045_/B _3574_/A _3472_/B VPWR VGND sg13g2_nor2_1
X_5141_ _5141_/Y _5149_/A VPWR VGND sg13g2_inv_1
X_5072_ _5072_/Y _5168_/A VPWR VGND sg13g2_inv_1
X_4023_ _4024_/B _4459_/A1 _3574_/A _3478_/Y _4069_/B2 VPWR VGND sg13g2_a22oi_1
XFILLER_56_118 VPWR VGND sg13g2_fill_1
XFILLER_25_505 VPWR VGND sg13g2_decap_8
XFILLER_37_343 VPWR VGND sg13g2_decap_8
XFILLER_64_151 VPWR VGND sg13g2_fill_1
XFILLER_25_549 VPWR VGND sg13g2_fill_1
XFILLER_64_162 VPWR VGND sg13g2_decap_8
X_4925_ _4925_/Y _5160_/A VPWR VGND sg13g2_inv_1
X_4856_ _4858_/B _5216_/Q _4856_/B _4856_/C VPWR VGND sg13g2_nand3_1
X_3807_ _3807_/Y _4001_/B2 _3765_/A _3764_/A _4069_/B2 VPWR VGND sg13g2_a22oi_1
X_4787_ _4799_/B _5209_/Q _5210_/Q _5211_/Q _4787_/D VPWR VGND sg13g2_nand4_1
X_3738_ _3739_/D _3920_/A _3660_/B _3615_/X VPWR VGND sg13g2_a21o_1
X_3669_ _3670_/D _5420_/Q _3682_/B1 _2817_/C VPWR VGND sg13g2_a21oi_1
X_5408_ _5408_/Q clkload8/A _5408_/D _5148_/Y VPWR VGND sg13g2_dfrbpq_1
XFILLER_0_626 VPWR VGND sg13g2_decap_4
X_5339_ _5339_/Q _5430_/CLK _5339_/D _5079_/Y VPWR VGND sg13g2_dfrbpq_1
XFILLER_18_21 VPWR VGND sg13g2_decap_4
XFILLER_28_321 VPWR VGND sg13g2_fill_2
XFILLER_16_516 VPWR VGND sg13g2_fill_2
XFILLER_28_354 VPWR VGND sg13g2_fill_1
XFILLER_43_335 VPWR VGND sg13g2_fill_2
XFILLER_55_195 VPWR VGND sg13g2_decap_4
XFILLER_34_42 VPWR VGND sg13g2_fill_1
XFILLER_11_254 VPWR VGND sg13g2_decap_8
XFILLER_50_85 VPWR VGND sg13g2_decap_8
XFILLER_3_431 VPWR VGND sg13g2_fill_2
XFILLER_66_427 VPWR VGND sg13g2_fill_2
XFILLER_66_416 VPWR VGND sg13g2_decap_8
XFILLER_15_7 VPWR VGND sg13g2_decap_8
XFILLER_47_641 VPWR VGND sg13g2_decap_8
XFILLER_19_365 VPWR VGND sg13g2_decap_8
XFILLER_46_151 VPWR VGND sg13g2_decap_8
XFILLER_62_633 VPWR VGND sg13g2_decap_8
XFILLER_34_368 VPWR VGND sg13g2_decap_8
XFILLER_61_121 VPWR VGND sg13g2_fill_1
X_2971_ _3060_/A _3823_/A _2971_/B VPWR VGND sg13g2_nor2_1
XFILLER_61_165 VPWR VGND sg13g2_decap_8
X_4710_ _4717_/B _4719_/B _4710_/B VPWR VGND sg13g2_xnor2_1
X_4641_ _4641_/Y _4641_/A _4641_/B VPWR VGND sg13g2_nand2_1
XFILLER_30_585 VPWR VGND sg13g2_fill_2
X_4572_ _4572_/Y _4572_/A _4619_/B VPWR VGND sg13g2_nor2_1
Xhold704 hold704/X _5301_/Q VPWR VGND sg13g2_dlygate4sd3_1
Xhold715 hold715/X _5306_/Q VPWR VGND sg13g2_dlygate4sd3_1
Xhold726 hold726/X _5269_/Q VPWR VGND sg13g2_dlygate4sd3_1
Xhold737 hold737/X _5317_/Q VPWR VGND sg13g2_dlygate4sd3_1
X_3523_ _3714_/B _4095_/B _3566_/B VPWR VGND sg13g2_xor2_1
Xhold748 hold748/X _5368_/Q VPWR VGND sg13g2_dlygate4sd3_1
Xhold759 hold759/X _5343_/Q VPWR VGND sg13g2_dlygate4sd3_1
X_3454_ _3489_/A _3999_/B _3983_/B VPWR VGND sg13g2_nand2_1
X_3385_ _3776_/A _3385_/A _3385_/B _3385_/C _3385_/D VPWR VGND sg13g2_nand4_1
X_5124_ _5124_/Y _5156_/A VPWR VGND sg13g2_inv_1
XFILLER_69_265 VPWR VGND sg13g2_decap_8
X_5055_ _5055_/Y _5154_/A VPWR VGND sg13g2_inv_1
X_4006_ _4008_/C _3427_/Y _4004_/Y _4005_/Y VPWR VGND sg13g2_a21o_1
XFILLER_72_408 VPWR VGND sg13g2_decap_4
XFILLER_37_184 VPWR VGND sg13g2_fill_1
XFILLER_52_110 VPWR VGND sg13g2_decap_8
XFILLER_25_335 VPWR VGND sg13g2_decap_8
XFILLER_52_132 VPWR VGND sg13g2_fill_1
X_4908_ _4908_/Y _4904_/Y _4907_/Y _4914_/A VPWR VGND sg13g2_o21ai_1
X_4839_ _4839_/Y _4839_/A _4840_/B VPWR VGND sg13g2_nor2_1
XFILLER_4_239 VPWR VGND sg13g2_decap_8
XFILLER_20_66 VPWR VGND sg13g2_decap_8
XFILLER_29_75 VPWR VGND sg13g2_decap_8
XFILLER_75_257 VPWR VGND sg13g2_decap_8
XFILLER_28_184 VPWR VGND sg13g2_decap_8
XFILLER_45_30 VPWR VGND sg13g2_fill_1
XFILLER_56_482 VPWR VGND sg13g2_decap_8
XFILLER_43_121 VPWR VGND sg13g2_fill_1
XFILLER_45_63 VPWR VGND sg13g2_decap_8
XFILLER_71_452 VPWR VGND sg13g2_fill_2
XFILLER_71_430 VPWR VGND sg13g2_decap_8
XFILLER_16_368 VPWR VGND sg13g2_decap_8
XFILLER_31_316 VPWR VGND sg13g2_fill_2
XFILLER_31_338 VPWR VGND sg13g2_fill_2
XFILLER_61_73 VPWR VGND sg13g2_decap_8
XFILLER_6_35 VPWR VGND sg13g2_decap_8
XFILLER_6_79 VPWR VGND sg13g2_fill_1
X_3170_ _3170_/Y _4207_/A _3162_/Y _3169_/Y VPWR VGND sg13g2_o21ai_1
XFILLER_13_4 VPWR VGND sg13g2_fill_2
XFILLER_34_132 VPWR VGND sg13g2_fill_1
XFILLER_22_316 VPWR VGND sg13g2_decap_8
XFILLER_34_154 VPWR VGND sg13g2_fill_1
XFILLER_62_452 VPWR VGND sg13g2_decap_8
XFILLER_50_647 VPWR VGND sg13g2_decap_4
X_2954_ _4201_/B _3721_/A _2970_/B VPWR VGND sg13g2_nand2b_1
X_2885_ _2887_/B _2656_/A _2656_/B _2879_/Y _2881_/Y _2882_/Y VPWR VGND sg13g2_a221oi_1
X_4624_ _4624_/Y _4624_/A _4630_/C VPWR VGND sg13g2_nand2_1
X_4555_ _4555_/Y _4555_/A _4555_/B VPWR VGND sg13g2_xnor2_1
X_3506_ _3506_/Y _4065_/A _3506_/B VPWR VGND sg13g2_nand2_1
X_4486_ _4486_/Y _5227_/Q _2999_/A _4485_/Y VPWR VGND sg13g2_o21ai_1
X_3437_ _3442_/A _3443_/A _2894_/B _3436_/Y VPWR VGND sg13g2_o21ai_1
X_3368_ _3368_/Y _3368_/A _3368_/B VPWR VGND sg13g2_nor2_1
XFILLER_57_202 VPWR VGND sg13g2_fill_2
X_5107_ _5107_/Y _5174_/A VPWR VGND sg13g2_inv_1
XFILLER_57_224 VPWR VGND sg13g2_fill_2
X_3299_ _3299_/Y _2974_/B _4209_/A1 _4211_/A2 _2974_/C VPWR VGND sg13g2_a22oi_1
X_5038_ _5038_/Y _5166_/A VPWR VGND sg13g2_inv_1
XFILLER_72_205 VPWR VGND sg13g2_decap_8
XFILLER_72_249 VPWR VGND sg13g2_fill_1
XFILLER_53_430 VPWR VGND sg13g2_decap_8
XFILLER_25_154 VPWR VGND sg13g2_decap_8
XFILLER_40_135 VPWR VGND sg13g2_decap_8
XFILLER_21_393 VPWR VGND sg13g2_decap_8
XFILLER_5_504 VPWR VGND sg13g2_decap_8
XFILLER_31_65 VPWR VGND sg13g2_fill_2
XFILLER_5_548 VPWR VGND sg13g2_decap_8
Xoutput98 dmem_addr[0] _4525_/Y VPWR VGND sg13g2_buf_1
XFILLER_17_600 VPWR VGND sg13g2_decap_8
XFILLER_56_62 VPWR VGND sg13g2_decap_4
XFILLER_56_290 VPWR VGND sg13g2_decap_8
XFILLER_32_614 VPWR VGND sg13g2_fill_1
XFILLER_44_496 VPWR VGND sg13g2_decap_4
XFILLER_31_135 VPWR VGND sg13g2_fill_1
XFILLER_12_393 VPWR VGND sg13g2_fill_1
X_2670_ _2670_/Y _2677_/A _4521_/A _2999_/B _2670_/D VPWR VGND sg13g2_nor4_1
X_4340_ _5308_/D _4261_/A hold692/X _4350_/S VPWR VGND sg13g2_mux2_1
XFILLER_4_581 VPWR VGND sg13g2_decap_8
X_4271_ _5366_/D _2782_/A _4273_/S _4270_/Y VPWR VGND sg13g2_o21ai_1
X_3222_ _3222_/Y _3222_/A _3222_/B VPWR VGND sg13g2_nand2_1
XFILLER_39_213 VPWR VGND sg13g2_fill_2
X_3153_ _3153_/X _3244_/A1 _4472_/A _3152_/Y VPWR VGND sg13g2_a21o_1
XFILLER_39_257 VPWR VGND sg13g2_fill_1
XFILLER_67_544 VPWR VGND sg13g2_decap_8
X_3084_ _3085_/D _4188_/B2 _2743_/X _3101_/A _4211_/A2 _3081_/Y VPWR VGND sg13g2_a221oi_1
XFILLER_47_290 VPWR VGND sg13g2_decap_8
XFILLER_23_625 VPWR VGND sg13g2_decap_8
XFILLER_50_455 VPWR VGND sg13g2_decap_8
X_3986_ _3986_/Y _2613_/Y _2685_/B _4009_/B1 VPWR VGND sg13g2_a21oi_1
X_2937_ _2939_/C _5431_/Q _2870_/B _3547_/B1 _5367_/Q VPWR VGND sg13g2_a22oi_1
X_4607_ _4607_/Y _4623_/C _4605_/X _4606_/Y VPWR VGND sg13g2_o21ai_1
X_2868_ _2869_/B _2974_/B _3027_/B _3027_/C VPWR VGND sg13g2_or3_1
X_2799_ _3161_/A _3166_/A _2799_/B VPWR VGND sg13g2_xnor2_1
X_4538_ _4538_/Y _4536_/Y _4537_/Y _4539_/B VPWR VGND sg13g2_o21ai_1
X_4469_ _4470_/D _4483_/B _4469_/B VPWR VGND sg13g2_or2_1
XFILLER_45_216 VPWR VGND sg13g2_fill_2
XFILLER_58_588 VPWR VGND sg13g2_decap_8
XFILLER_26_452 VPWR VGND sg13g2_decap_8
XFILLER_14_625 VPWR VGND sg13g2_decap_8
XFILLER_53_282 VPWR VGND sg13g2_decap_4
XFILLER_9_128 VPWR VGND sg13g2_decap_8
XFILLER_21_190 VPWR VGND sg13g2_decap_8
XFILLER_5_301 VPWR VGND sg13g2_decap_8
XFILLER_3_14 VPWR VGND sg13g2_decap_8
XFILLER_68_308 VPWR VGND sg13g2_fill_2
XFILLER_49_522 VPWR VGND sg13g2_decap_8
XFILLER_64_536 VPWR VGND sg13g2_fill_1
XFILLER_17_441 VPWR VGND sg13g2_decap_8
XFILLER_17_452 VPWR VGND sg13g2_fill_2
XFILLER_17_474 VPWR VGND sg13g2_fill_2
X_3840_ _3840_/Y _2620_/Y _3889_/B _3838_/Y _3839_/Y VPWR VGND sg13g2_a22oi_1
X_3771_ _4452_/B _3771_/A _3771_/B _3771_/C _3771_/D VPWR VGND sg13g2_nor4_1
XFILLER_80_4 VPWR VGND sg13g2_decap_8
X_2722_ _2722_/Y _2722_/A _2722_/B VPWR VGND sg13g2_nor2_1
X_5441_ _5441_/X _5441_/A VPWR VGND sg13g2_buf_1
X_2653_ _4520_/A _2678_/B _2653_/B VPWR VGND sg13g2_nand2b_1
X_5372_ _5372_/Q _5434_/CLK _5372_/D _5112_/Y VPWR VGND sg13g2_dfrbpq_1
X_2584_ _2584_/Y _2584_/A VPWR VGND sg13g2_inv_1
X_4323_ _5323_/D _3860_/Y hold820/X _4329_/S VPWR VGND sg13g2_mux2_1
X_4254_ _5377_/D _2545_/Y _4276_/B _4253_/Y VPWR VGND sg13g2_o21ai_1
X_4185_ _4185_/Y _4185_/A _4185_/B _4185_/C VPWR VGND sg13g2_nor3_1
X_3205_ _3205_/X _3210_/B _3205_/B VPWR VGND sg13g2_or2_1
X_3136_ _3136_/Y _2589_/Y _3154_/B1 _3134_/X _3135_/Y VPWR VGND sg13g2_a22oi_1
XFILLER_55_525 VPWR VGND sg13g2_fill_1
X_3067_ _3067_/Y _3134_/A1 _3061_/A _3066_/Y VPWR VGND sg13g2_a21oi_1
XFILLER_55_569 VPWR VGND sg13g2_decap_8
XFILLER_11_606 VPWR VGND sg13g2_decap_8
XFILLER_50_230 VPWR VGND sg13g2_decap_4
XFILLER_10_116 VPWR VGND sg13g2_decap_8
XFILLER_11_628 VPWR VGND sg13g2_decap_8
X_3969_ _3969_/Y _3936_/A _3756_/A _3938_/B _4001_/B2 VPWR VGND sg13g2_a22oi_1
XFILLER_12_23 VPWR VGND sg13g2_fill_1
XFILLER_2_337 VPWR VGND sg13g2_decap_8
XFILLER_73_333 VPWR VGND sg13g2_decap_8
XFILLER_73_366 VPWR VGND sg13g2_decap_8
XFILLER_26_260 VPWR VGND sg13g2_decap_8
XFILLER_61_539 VPWR VGND sg13g2_decap_8
XFILLER_14_433 VPWR VGND sg13g2_decap_4
XFILLER_41_263 VPWR VGND sg13g2_decap_8
XFILLER_6_621 VPWR VGND sg13g2_fill_2
XFILLER_6_610 VPWR VGND sg13g2_decap_8
XFILLER_45_7 VPWR VGND sg13g2_decap_8
XFILLER_69_606 VPWR VGND sg13g2_decap_8
XFILLER_68_105 VPWR VGND sg13g2_decap_8
XFILLER_1_381 VPWR VGND sg13g2_decap_4
XFILLER_49_341 VPWR VGND sg13g2_decap_8
XFILLER_64_333 VPWR VGND sg13g2_decap_8
XFILLER_64_311 VPWR VGND sg13g2_decap_8
XFILLER_17_260 VPWR VGND sg13g2_decap_8
X_4941_ _4941_/Y _4942_/A VPWR VGND sg13g2_inv_1
X_4872_ _4872_/Y _4880_/B _4872_/B VPWR VGND sg13g2_nand2b_1
XFILLER_20_403 VPWR VGND sg13g2_decap_8
X_3823_ _3823_/X _3823_/A _3823_/B VPWR VGND sg13g2_or2_1
XFILLER_20_458 VPWR VGND sg13g2_decap_8
X_3754_ _4067_/A _4065_/A _3973_/A _4093_/B VPWR VGND sg13g2_nand3_1
XFILLER_71_0 VPWR VGND sg13g2_decap_8
X_3685_ _3686_/D _5259_/Q _3685_/B VPWR VGND sg13g2_nand2_1
X_2705_ _2705_/Y _2895_/D _2820_/B VPWR VGND sg13g2_nor2b_1
X_5424_ _5424_/Q _5424_/CLK _5424_/D _5164_/Y VPWR VGND sg13g2_dfrbpq_1
Xoutput200 io_wdata[12] _5448_/X VPWR VGND sg13g2_buf_1
X_2636_ _2956_/C _2677_/A _2636_/B VPWR VGND sg13g2_nand2_1
Xoutput211 io_wdata[22] _5458_/X VPWR VGND sg13g2_buf_1
Xoutput222 io_wdata[3] _5439_/X VPWR VGND sg13g2_buf_1
X_5355_ _5355_/Q _5421_/CLK _5355_/D _5095_/Y VPWR VGND sg13g2_dfrbpq_1
X_2567_ _2656_/A _4489_/B VPWR VGND sg13g2_inv_1
X_5286_ _5286_/Q clkload6/A _5286_/D _5026_/Y VPWR VGND sg13g2_dfrbpq_1
X_4306_ _5338_/D _3093_/Y hold695/X _4312_/S VPWR VGND sg13g2_mux2_1
X_4237_ _5391_/D hold743/X _4427_/A _4237_/S VPWR VGND sg13g2_mux2_1
XFILLER_28_536 VPWR VGND sg13g2_decap_4
XFILLER_28_558 VPWR VGND sg13g2_decap_4
X_4168_ _4174_/C _4168_/A _4168_/B _4168_/C _4168_/D VPWR VGND sg13g2_nor4_1
XFILLER_67_193 VPWR VGND sg13g2_fill_2
XFILLER_43_517 VPWR VGND sg13g2_decap_8
X_4099_ _4099_/Y _4099_/A _4099_/B _4099_/C _4099_/D VPWR VGND sg13g2_nand4_1
X_3119_ _3125_/B _3099_/B _3119_/B VPWR VGND sg13g2_nand2b_1
XFILLER_55_355 VPWR VGND sg13g2_decap_8
XFILLER_70_325 VPWR VGND sg13g2_decap_4
XFILLER_36_591 VPWR VGND sg13g2_decap_8
XFILLER_23_11 VPWR VGND sg13g2_fill_1
XFILLER_11_447 VPWR VGND sg13g2_decap_8
XFILLER_23_296 VPWR VGND sg13g2_decap_8
XFILLER_11_458 VPWR VGND sg13g2_fill_1
XFILLER_23_88 VPWR VGND sg13g2_fill_1
XFILLER_7_407 VPWR VGND sg13g2_decap_8
XFILLER_3_624 VPWR VGND sg13g2_fill_2
XFILLER_78_469 VPWR VGND sg13g2_fill_2
XFILLER_78_458 VPWR VGND sg13g2_decap_8
XFILLER_19_503 VPWR VGND sg13g2_decap_8
Xfanout460 _3508_/B _2703_/X VPWR VGND sg13g2_buf_1
Xfanout471 _3548_/A2 _2698_/Y VPWR VGND sg13g2_buf_1
Xfanout482 _3102_/A _2672_/Y VPWR VGND sg13g2_buf_1
Xfanout493 _3704_/A _2655_/Y VPWR VGND sg13g2_buf_1
XFILLER_19_536 VPWR VGND sg13g2_decap_8
XFILLER_46_311 VPWR VGND sg13g2_decap_8
XFILLER_46_322 VPWR VGND sg13g2_fill_1
XFILLER_46_366 VPWR VGND sg13g2_decap_8
XFILLER_46_377 VPWR VGND sg13g2_fill_2
XFILLER_61_347 VPWR VGND sg13g2_fill_1
XFILLER_9_68 VPWR VGND sg13g2_decap_8
XFILLER_80_61 VPWR VGND sg13g2_decap_8
XFILLER_10_491 VPWR VGND sg13g2_fill_2
XFILLER_6_451 VPWR VGND sg13g2_fill_2
X_3470_ _4029_/A _3574_/A _3472_/B VPWR VGND sg13g2_nand2_1
XFILLER_43_4 VPWR VGND sg13g2_fill_2
X_5140_ _5140_/Y _5172_/A VPWR VGND sg13g2_inv_1
X_5071_ _5071_/Y _5167_/A VPWR VGND sg13g2_inv_1
X_4022_ _4025_/B _4045_/A _3708_/B _4021_/Y VPWR VGND sg13g2_o21ai_1
XFILLER_37_311 VPWR VGND sg13g2_decap_8
XFILLER_18_580 VPWR VGND sg13g2_decap_8
XFILLER_37_377 VPWR VGND sg13g2_decap_4
XFILLER_52_314 VPWR VGND sg13g2_decap_8
XFILLER_52_358 VPWR VGND sg13g2_decap_8
X_4924_ _4924_/Y _5152_/A VPWR VGND sg13g2_inv_1
XFILLER_33_572 VPWR VGND sg13g2_fill_1
XFILLER_20_233 VPWR VGND sg13g2_decap_4
XFILLER_33_594 VPWR VGND sg13g2_decap_8
X_4855_ _4861_/A _4852_/A _4867_/A _4869_/A VPWR VGND sg13g2_o21ai_1
X_4786_ _5210_/D _4796_/A _4785_/Y _4782_/Y VPWR VGND sg13g2_a21oi_1
X_3806_ _3810_/B _3764_/A _3359_/B _3805_/Y VPWR VGND sg13g2_a21oi_1
X_3737_ _3737_/X _3868_/A _3739_/C _3737_/C VPWR VGND sg13g2_and3_1
X_3668_ _3670_/C _5356_/Q _3668_/A2 _3668_/B1 _5292_/Q VPWR VGND sg13g2_a22oi_1
X_5407_ _5407_/Q _5414_/CLK _5407_/D _5147_/Y VPWR VGND sg13g2_dfrbpq_1
X_3599_ _3739_/A _3660_/B _4445_/A VPWR VGND sg13g2_nand2b_1
X_2619_ _2619_/Y _2619_/A VPWR VGND sg13g2_inv_1
XFILLER_0_605 VPWR VGND sg13g2_decap_8
X_5338_ _5338_/Q _5434_/CLK _5338_/D _5078_/Y VPWR VGND sg13g2_dfrbpq_1
XFILLER_0_649 VPWR VGND sg13g2_fill_2
XFILLER_48_609 VPWR VGND sg13g2_decap_8
X_5269_ _5269_/Q _5435_/CLK _5269_/D _5009_/Y VPWR VGND sg13g2_dfrbpq_1
XFILLER_75_417 VPWR VGND sg13g2_decap_8
XFILLER_75_406 VPWR VGND sg13g2_decap_4
XFILLER_68_491 VPWR VGND sg13g2_fill_2
XFILLER_68_480 VPWR VGND sg13g2_decap_8
XFILLER_71_601 VPWR VGND sg13g2_decap_8
XFILLER_28_377 VPWR VGND sg13g2_fill_2
XFILLER_28_388 VPWR VGND sg13g2_decap_8
XFILLER_55_174 VPWR VGND sg13g2_fill_1
XFILLER_34_21 VPWR VGND sg13g2_decap_8
XFILLER_43_347 VPWR VGND sg13g2_decap_8
XFILLER_24_561 VPWR VGND sg13g2_decap_4
XFILLER_70_166 VPWR VGND sg13g2_fill_2
XFILLER_11_211 VPWR VGND sg13g2_decap_8
XFILLER_11_222 VPWR VGND sg13g2_decap_8
XFILLER_34_87 VPWR VGND sg13g2_decap_8
XFILLER_51_391 VPWR VGND sg13g2_fill_2
XFILLER_7_237 VPWR VGND sg13g2_fill_1
XFILLER_50_64 VPWR VGND sg13g2_decap_8
XFILLER_3_443 VPWR VGND sg13g2_decap_8
XFILLER_1_0 VPWR VGND sg13g2_decap_8
XFILLER_78_200 VPWR VGND sg13g2_decap_4
XFILLER_78_277 VPWR VGND sg13g2_decap_4
XFILLER_19_300 VPWR VGND sg13g2_decap_4
Xfanout290 _4914_/A _4701_/A1 VPWR VGND sg13g2_buf_1
XFILLER_59_480 VPWR VGND sg13g2_decap_4
XFILLER_19_344 VPWR VGND sg13g2_decap_8
XFILLER_74_494 VPWR VGND sg13g2_fill_2
XFILLER_34_347 VPWR VGND sg13g2_decap_8
X_2970_ _2971_/B _3721_/A _2970_/B VPWR VGND sg13g2_xor2_1
XFILLER_15_583 VPWR VGND sg13g2_decap_4
XFILLER_15_594 VPWR VGND sg13g2_fill_1
XFILLER_30_531 VPWR VGND sg13g2_decap_8
X_4640_ _4640_/Y _4636_/Y _4638_/Y _4642_/S VPWR VGND sg13g2_o21ai_1
X_4571_ _4571_/X _5449_/A _4571_/B VPWR VGND sg13g2_xor2_1
Xhold705 hold705/X _5347_/Q VPWR VGND sg13g2_dlygate4sd3_1
Xhold716 _2556_/A _5359_/Q VPWR VGND sg13g2_dlygate4sd3_1
Xhold727 hold727/X _5314_/Q VPWR VGND sg13g2_dlygate4sd3_1
X_3522_ _3522_/X _4095_/B _3566_/B VPWR VGND sg13g2_and2_1
Xhold738 hold738/X _5305_/Q VPWR VGND sg13g2_dlygate4sd3_1
Xhold749 hold749/X _5328_/Q VPWR VGND sg13g2_dlygate4sd3_1
X_3453_ _3983_/B _3936_/B _3453_/B VPWR VGND sg13g2_xnor2_1
XFILLER_34_0 VPWR VGND sg13g2_decap_8
X_5123_ _5123_/Y _5159_/A VPWR VGND sg13g2_inv_1
X_3384_ _4185_/C _3385_/A _3385_/B _3385_/C _3385_/D VPWR VGND sg13g2_and4_1
X_5054_ _5054_/Y _5150_/A VPWR VGND sg13g2_inv_1
X_4005_ _4005_/Y _3771_/B _4043_/B _4043_/A VPWR VGND sg13g2_o21ai_1
XFILLER_37_163 VPWR VGND sg13g2_decap_4
XFILLER_37_174 VPWR VGND sg13g2_decap_4
XFILLER_40_306 VPWR VGND sg13g2_fill_1
XFILLER_40_339 VPWR VGND sg13g2_fill_1
XFILLER_52_188 VPWR VGND sg13g2_decap_8
X_4907_ _4907_/Y _4890_/B _4905_/Y _4906_/Y VPWR VGND sg13g2_a21oi_1
XFILLER_21_553 VPWR VGND sg13g2_decap_8
X_4838_ _4840_/B _4838_/A _4856_/C VPWR VGND sg13g2_xor2_1
X_4769_ _4769_/Y _4814_/A _4769_/B VPWR VGND sg13g2_nor2_1
XFILLER_4_229 VPWR VGND sg13g2_fill_1
XFILLER_0_479 VPWR VGND sg13g2_decap_8
XFILLER_29_54 VPWR VGND sg13g2_decap_8
XFILLER_75_236 VPWR VGND sg13g2_decap_8
XFILLER_16_314 VPWR VGND sg13g2_decap_8
XFILLER_16_325 VPWR VGND sg13g2_fill_1
XFILLER_28_196 VPWR VGND sg13g2_decap_8
XFILLER_43_166 VPWR VGND sg13g2_decap_8
XFILLER_71_486 VPWR VGND sg13g2_decap_8
XFILLER_12_520 VPWR VGND sg13g2_decap_8
XFILLER_8_502 VPWR VGND sg13g2_fill_2
XFILLER_8_557 VPWR VGND sg13g2_fill_1
XFILLER_6_25 VPWR VGND sg13g2_fill_1
XFILLER_3_262 VPWR VGND sg13g2_fill_1
XFILLER_39_406 VPWR VGND sg13g2_decap_8
XFILLER_39_439 VPWR VGND sg13g2_decap_8
XFILLER_66_236 VPWR VGND sg13g2_decap_8
XFILLER_19_130 VPWR VGND sg13g2_fill_2
XFILLER_47_450 VPWR VGND sg13g2_decap_8
XFILLER_66_269 VPWR VGND sg13g2_decap_4
XFILLER_35_601 VPWR VGND sg13g2_decap_8
XFILLER_47_483 VPWR VGND sg13g2_decap_8
XFILLER_81_217 VPWR VGND sg13g2_decap_8
XFILLER_62_431 VPWR VGND sg13g2_decap_8
XFILLER_15_380 VPWR VGND sg13g2_decap_8
XFILLER_50_626 VPWR VGND sg13g2_decap_8
X_2953_ _2970_/B _2764_/Y _3097_/B _2759_/Y VPWR VGND sg13g2_o21ai_1
XFILLER_62_497 VPWR VGND sg13g2_fill_1
X_2884_ _5436_/A _2884_/A VPWR VGND sg13g2_inv_1
X_4623_ _4630_/C _5461_/A _5460_/A _4623_/C _4623_/D VPWR VGND sg13g2_or4_1
X_4554_ _4564_/C _5445_/A _4555_/A VPWR VGND sg13g2_or2_1
X_3505_ _4068_/B _4065_/A _3506_/B VPWR VGND sg13g2_nor2_1
X_4485_ _4485_/Y _4485_/A _4521_/B VPWR VGND sg13g2_nand2_1
X_3436_ _3436_/Y _5350_/Q _3668_/A2 _3668_/B1 _5286_/Q VPWR VGND sg13g2_a22oi_1
X_3367_ _4440_/D _4438_/A VPWR VGND sg13g2_inv_1
X_5106_ _5106_/Y _5138_/A VPWR VGND sg13g2_inv_1
XFILLER_57_236 VPWR VGND sg13g2_decap_8
X_5037_ _5037_/Y _5167_/A VPWR VGND sg13g2_inv_1
X_3298_ _3302_/C _3298_/A _3298_/B VPWR VGND sg13g2_and2_1
XFILLER_26_612 VPWR VGND sg13g2_decap_8
XFILLER_26_623 VPWR VGND sg13g2_fill_1
XFILLER_38_450 VPWR VGND sg13g2_decap_8
XFILLER_25_133 VPWR VGND sg13g2_decap_8
XFILLER_65_291 VPWR VGND sg13g2_decap_4
XFILLER_15_23 VPWR VGND sg13g2_fill_1
XFILLER_41_604 VPWR VGND sg13g2_decap_8
XFILLER_15_34 VPWR VGND sg13g2_decap_4
XFILLER_80_294 VPWR VGND sg13g2_fill_2
XFILLER_15_78 VPWR VGND sg13g2_fill_2
XFILLER_21_372 VPWR VGND sg13g2_decap_4
XFILLER_31_44 VPWR VGND sg13g2_fill_1
Xrebuffer610 _5439_/A _4530_/A VPWR VGND sg13g2_buf_1
Xoutput99 dmem_addr[10] _4558_/X VPWR VGND sg13g2_buf_1
XFILLER_76_523 VPWR VGND sg13g2_decap_4
XFILLER_36_409 VPWR VGND sg13g2_decap_8
XFILLER_56_41 VPWR VGND sg13g2_decap_8
XFILLER_29_472 VPWR VGND sg13g2_decap_8
XFILLER_76_589 VPWR VGND sg13g2_fill_1
XFILLER_44_420 VPWR VGND sg13g2_decap_8
XFILLER_31_103 VPWR VGND sg13g2_decap_8
XFILLER_32_626 VPWR VGND sg13g2_decap_8
XFILLER_32_637 VPWR VGND sg13g2_fill_2
XFILLER_71_283 VPWR VGND sg13g2_decap_8
XFILLER_31_158 VPWR VGND sg13g2_fill_1
XFILLER_12_350 VPWR VGND sg13g2_fill_1
XFILLER_75_7 VPWR VGND sg13g2_decap_4
XFILLER_8_387 VPWR VGND sg13g2_decap_8
XFILLER_68_6 VPWR VGND sg13g2_fill_1
X_4270_ _4270_/Y _4348_/A _4273_/S VPWR VGND sg13g2_nand2_1
X_3221_ _3221_/Y _4670_/A _4195_/A2 _3220_/Y VPWR VGND sg13g2_a21oi_1
XFILLER_79_361 VPWR VGND sg13g2_fill_2
X_3152_ _3152_/Y input95/X _3244_/A1 _3065_/B VPWR VGND sg13g2_o21ai_1
XFILLER_79_372 VPWR VGND sg13g2_fill_2
XFILLER_67_523 VPWR VGND sg13g2_decap_8
X_3083_ _3085_/C _4188_/A1 _2744_/X _4209_/A1 _4441_/C VPWR VGND sg13g2_a22oi_1
XFILLER_54_217 VPWR VGND sg13g2_fill_2
XFILLER_47_280 VPWR VGND sg13g2_fill_2
XFILLER_23_615 VPWR VGND sg13g2_decap_4
XFILLER_22_103 VPWR VGND sg13g2_decap_8
XFILLER_50_434 VPWR VGND sg13g2_decap_8
X_3985_ _4481_/C _3985_/A _3985_/B _3985_/C VPWR VGND sg13g2_nand3_1
X_2936_ _2939_/B _5399_/Q _3004_/B1 _3003_/B1 _5271_/Q VPWR VGND sg13g2_a22oi_1
XFILLER_30_180 VPWR VGND sg13g2_fill_2
X_2867_ _2867_/Y _2974_/B _3027_/B _3027_/C VPWR VGND sg13g2_nor3_1
X_4606_ _4606_/Y _2716_/A _4621_/A _5457_/A _4618_/B2 VPWR VGND sg13g2_a22oi_1
X_2798_ _2916_/B _3166_/A _2799_/B VPWR VGND sg13g2_nor2_1
X_4537_ _4537_/Y _2576_/A _4543_/A _4535_/B VPWR VGND sg13g2_o21ai_1
X_4468_ _4468_/Y _4468_/A _4483_/B VPWR VGND sg13g2_nand2_1
X_3419_ _3419_/Y _3721_/C _4172_/A _3418_/Y VPWR VGND sg13g2_a21oi_1
X_4399_ _5258_/D _3890_/Y hold730/X _4409_/S VPWR VGND sg13g2_mux2_1
XFILLER_58_512 VPWR VGND sg13g2_fill_2
XFILLER_58_556 VPWR VGND sg13g2_decap_8
XFILLER_26_431 VPWR VGND sg13g2_decap_8
XFILLER_73_559 VPWR VGND sg13g2_decap_4
XFILLER_14_604 VPWR VGND sg13g2_decap_8
XFILLER_26_44 VPWR VGND sg13g2_decap_8
XFILLER_53_250 VPWR VGND sg13g2_fill_1
XFILLER_13_136 VPWR VGND sg13g2_decap_8
XFILLER_41_456 VPWR VGND sg13g2_decap_8
XFILLER_9_107 VPWR VGND sg13g2_fill_2
XFILLER_42_21 VPWR VGND sg13g2_fill_1
XFILLER_42_98 VPWR VGND sg13g2_decap_8
XFILLER_49_567 VPWR VGND sg13g2_decap_8
XFILLER_64_515 VPWR VGND sg13g2_decap_8
XFILLER_76_397 VPWR VGND sg13g2_decap_8
XFILLER_17_486 VPWR VGND sg13g2_fill_2
X_3770_ _3771_/D _4450_/C _4448_/D _4449_/B VPWR VGND sg13g2_nand3_1
XFILLER_12_180 VPWR VGND sg13g2_fill_1
X_2721_ _2727_/A _5307_/Q _2879_/A2 _3371_/A2 _5275_/Q VPWR VGND sg13g2_a22oi_1
XFILLER_12_191 VPWR VGND sg13g2_fill_2
X_5440_ _5440_/X _5440_/A VPWR VGND sg13g2_buf_1
X_2652_ _4521_/C _2678_/B _2653_/B VPWR VGND sg13g2_nor2b_1
X_5371_ _5371_/Q _5430_/CLK _5371_/D _5111_/Y VPWR VGND sg13g2_dfrbpq_1
X_2583_ _2583_/Y _2583_/A VPWR VGND sg13g2_inv_1
X_4322_ _5324_/D _3840_/Y hold790/X _4329_/S VPWR VGND sg13g2_mux2_1
X_4253_ _4253_/Y _4253_/A _4276_/B VPWR VGND sg13g2_nand2_1
X_3204_ _3204_/Y _3204_/A _3204_/B VPWR VGND sg13g2_xnor2_1
X_4184_ _4184_/Y _4438_/A _4184_/B VPWR VGND sg13g2_xnor2_1
XFILLER_67_331 VPWR VGND sg13g2_decap_8
X_3135_ _3135_/Y _4706_/A _3135_/A2 _3154_/B1 VPWR VGND sg13g2_a21oi_1
XFILLER_67_353 VPWR VGND sg13g2_fill_1
XFILLER_27_228 VPWR VGND sg13g2_decap_8
X_3066_ _3066_/Y input68/X _3887_/B _3064_/Y VPWR VGND sg13g2_o21ai_1
XFILLER_55_559 VPWR VGND sg13g2_fill_2
XFILLER_63_581 VPWR VGND sg13g2_decap_8
XFILLER_23_456 VPWR VGND sg13g2_decap_8
XFILLER_23_478 VPWR VGND sg13g2_decap_8
X_3968_ _3978_/B _3968_/A VPWR VGND sg13g2_inv_1
X_2919_ _2925_/A _5240_/Q _2938_/B VPWR VGND sg13g2_nand2_1
X_3899_ _3899_/Y _3879_/A _3656_/B _3898_/Y VPWR VGND sg13g2_o21ai_1
XFILLER_78_607 VPWR VGND sg13g2_decap_8
XFILLER_58_320 VPWR VGND sg13g2_fill_2
XFILLER_73_301 VPWR VGND sg13g2_fill_2
XFILLER_18_239 VPWR VGND sg13g2_decap_4
XFILLER_46_526 VPWR VGND sg13g2_decap_8
XFILLER_58_386 VPWR VGND sg13g2_decap_8
XFILLER_61_518 VPWR VGND sg13g2_decap_8
XFILLER_14_412 VPWR VGND sg13g2_decap_8
XFILLER_54_570 VPWR VGND sg13g2_fill_2
XFILLER_53_75 VPWR VGND sg13g2_decap_8
XFILLER_41_297 VPWR VGND sg13g2_decap_8
XFILLER_10_651 VPWR VGND sg13g2_fill_1
XFILLER_5_187 VPWR VGND sg13g2_decap_4
XFILLER_5_176 VPWR VGND sg13g2_fill_1
XFILLER_77_651 VPWR VGND sg13g2_fill_1
XFILLER_77_640 VPWR VGND sg13g2_decap_8
XFILLER_37_559 VPWR VGND sg13g2_fill_2
XFILLER_52_518 VPWR VGND sg13g2_fill_2
X_4940_ _4940_/Y _4942_/A VPWR VGND sg13g2_inv_1
X_4871_ _4872_/B _4885_/A _4871_/B _4886_/B VPWR VGND sg13g2_nand3_1
XFILLER_32_242 VPWR VGND sg13g2_fill_1
X_3822_ _3822_/Y _3820_/B _3856_/B _4088_/B VPWR VGND sg13g2_o21ai_1
XFILLER_20_437 VPWR VGND sg13g2_decap_8
XFILLER_60_595 VPWR VGND sg13g2_decap_8
X_3753_ _3755_/D _4185_/C _4114_/A _3973_/C _4160_/B VPWR VGND sg13g2_nand4_1
X_3684_ _3686_/C _5191_/Q _3456_/B _3684_/B1 _5291_/Q VPWR VGND sg13g2_a22oi_1
X_2704_ _2894_/B _2694_/B _2704_/B _2704_/C VPWR VGND sg13g2_nand3b_1
X_5423_ _5423_/Q _5424_/CLK _5423_/D _5163_/Y VPWR VGND sg13g2_dfrbpq_1
Xoutput201 io_wdata[13] _5449_/X VPWR VGND sg13g2_buf_1
X_2635_ _2682_/B _2667_/B _2677_/A VPWR VGND sg13g2_nor2b_1
X_5354_ _5354_/Q _5421_/CLK _5354_/D _5094_/Y VPWR VGND sg13g2_dfrbpq_1
Xoutput212 io_wdata[23] _5459_/X VPWR VGND sg13g2_buf_1
Xoutput223 io_wdata[4] _5440_/X VPWR VGND sg13g2_buf_1
X_4305_ _5339_/D _3068_/Y _4312_/S _4304_/Y VPWR VGND sg13g2_o21ai_1
X_2566_ _2636_/B _4521_/A VPWR VGND sg13g2_inv_1
X_5285_ _5285_/Q clkload5/A _5285_/D _5025_/Y VPWR VGND sg13g2_dfrbpq_1
X_4236_ _5392_/D hold697/X _4280_/A _4236_/S VPWR VGND sg13g2_mux2_1
XFILLER_28_515 VPWR VGND sg13g2_fill_1
X_4167_ _4168_/D _4207_/A _4167_/B VPWR VGND sg13g2_nor2_1
XFILLER_68_651 VPWR VGND sg13g2_fill_1
XFILLER_55_301 VPWR VGND sg13g2_decap_8
X_3118_ _3119_/B _4436_/C _3140_/B _2993_/A VPWR VGND sg13g2_o21ai_1
XFILLER_67_172 VPWR VGND sg13g2_fill_2
XFILLER_43_507 VPWR VGND sg13g2_fill_2
X_4098_ _4099_/D _3210_/A _3522_/X _3714_/B _3102_/A VPWR VGND sg13g2_a22oi_1
X_3049_ _3129_/A _3139_/B _3138_/B VPWR VGND sg13g2_nor2_1
XFILLER_70_348 VPWR VGND sg13g2_decap_8
XFILLER_11_426 VPWR VGND sg13g2_fill_1
XFILLER_23_23 VPWR VGND sg13g2_fill_2
XFILLER_23_275 VPWR VGND sg13g2_decap_8
XFILLER_23_34 VPWR VGND sg13g2_decap_8
XFILLER_51_584 VPWR VGND sg13g2_decap_8
XFILLER_2_168 VPWR VGND sg13g2_fill_2
XFILLER_78_415 VPWR VGND sg13g2_decap_4
Xfanout450 _3677_/B _2926_/B VPWR VGND sg13g2_buf_4
Xfanout461 _3361_/B _3004_/B1 VPWR VGND sg13g2_buf_1
Xfanout472 _3581_/B _3492_/B VPWR VGND sg13g2_buf_1
Xfanout483 _4139_/A1 _2672_/Y VPWR VGND sg13g2_buf_1
Xfanout494 _3878_/A _2646_/Y VPWR VGND sg13g2_buf_1
XFILLER_46_345 VPWR VGND sg13g2_decap_8
XFILLER_42_595 VPWR VGND sg13g2_decap_8
XFILLER_80_40 VPWR VGND sg13g2_decap_8
XFILLER_10_470 VPWR VGND sg13g2_decap_8
XFILLER_6_430 VPWR VGND sg13g2_decap_8
XFILLER_69_415 VPWR VGND sg13g2_decap_4
X_5070_ _5070_/Y _5166_/A VPWR VGND sg13g2_inv_1
X_4021_ _4021_/Y _3847_/A _3756_/A _4019_/B _4095_/A VPWR VGND sg13g2_a22oi_1
XFILLER_37_356 VPWR VGND sg13g2_decap_8
X_4923_ _4923_/Y _5156_/A VPWR VGND sg13g2_inv_1
X_4854_ _5217_/D _4839_/A hold857/X _4853_/Y VPWR VGND sg13g2_o21ai_1
XFILLER_20_256 VPWR VGND sg13g2_decap_8
X_4785_ _4785_/Y _4785_/A _4808_/B VPWR VGND sg13g2_xnor2_1
X_3805_ _3805_/Y _3938_/A _4448_/A _3357_/Y _4068_/A _3896_/A VPWR VGND sg13g2_a221oi_1
X_3736_ _3737_/C _3916_/B _3736_/B VPWR VGND sg13g2_nor2_1
X_3667_ _3670_/B _5192_/Q _3637_/B _3581_/B _5388_/Q VPWR VGND sg13g2_a22oi_1
X_5406_ _5406_/Q clkload8/A _5406_/D _5146_/Y VPWR VGND sg13g2_dfrbpq_1
X_3598_ _3600_/A _3920_/A _3660_/B VPWR VGND sg13g2_nand2_1
X_2618_ _2618_/Y _2618_/A VPWR VGND sg13g2_inv_1
X_5337_ _5337_/Q clkload9/A _5337_/D _5077_/Y VPWR VGND sg13g2_dfrbpq_1
X_2549_ _2549_/Y _2549_/A VPWR VGND sg13g2_inv_1
X_5268_ _5268_/Q _5435_/CLK _5268_/D _5008_/Y VPWR VGND sg13g2_dfrbpq_1
XFILLER_47_109 VPWR VGND sg13g2_decap_4
X_4219_ _4261_/A _2595_/Y _4219_/A2 _4217_/Y _4218_/Y VPWR VGND sg13g2_a22oi_1
XFILLER_18_34 VPWR VGND sg13g2_decap_8
XFILLER_28_301 VPWR VGND sg13g2_decap_4
XFILLER_28_312 VPWR VGND sg13g2_fill_1
XFILLER_28_323 VPWR VGND sg13g2_fill_1
X_5199_ _5199_/Q _5206_/CLK _5199_/D _4939_/Y VPWR VGND sg13g2_dfrbpq_1
XFILLER_16_518 VPWR VGND sg13g2_fill_1
XFILLER_18_78 VPWR VGND sg13g2_decap_8
XFILLER_43_337 VPWR VGND sg13g2_fill_1
XFILLER_70_134 VPWR VGND sg13g2_decap_4
XFILLER_70_189 VPWR VGND sg13g2_decap_8
XFILLER_11_289 VPWR VGND sg13g2_decap_8
XFILLER_50_43 VPWR VGND sg13g2_decap_8
XFILLER_7_249 VPWR VGND sg13g2_decap_8
XFILLER_3_400 VPWR VGND sg13g2_fill_1
XFILLER_3_411 VPWR VGND sg13g2_fill_1
XFILLER_3_422 VPWR VGND sg13g2_decap_4
XFILLER_3_466 VPWR VGND sg13g2_decap_4
Xfanout280 _3856_/A _3057_/Y VPWR VGND sg13g2_buf_1
Xfanout291 _4878_/A _4701_/A1 VPWR VGND sg13g2_buf_1
XFILLER_46_175 VPWR VGND sg13g2_fill_2
XFILLER_34_326 VPWR VGND sg13g2_decap_8
XFILLER_46_186 VPWR VGND sg13g2_fill_2
XFILLER_15_562 VPWR VGND sg13g2_decap_8
XFILLER_30_510 VPWR VGND sg13g2_decap_4
XFILLER_42_370 VPWR VGND sg13g2_decap_4
XFILLER_30_554 VPWR VGND sg13g2_fill_2
XFILLER_30_565 VPWR VGND sg13g2_decap_8
XFILLER_30_598 VPWR VGND sg13g2_decap_8
X_4570_ _4571_/B _4575_/D _4575_/C VPWR VGND sg13g2_or2_1
X_3521_ _3566_/B _4360_/A _5454_/A _3559_/S VPWR VGND sg13g2_mux2_1
Xhold706 hold706/X _5251_/Q VPWR VGND sg13g2_dlygate4sd3_1
Xhold717 hold717/X _5234_/Q VPWR VGND sg13g2_dlygate4sd3_1
Xhold728 hold728/X _5315_/Q VPWR VGND sg13g2_dlygate4sd3_1
Xhold739 hold739/X _5281_/Q VPWR VGND sg13g2_dlygate4sd3_1
X_3452_ _3961_/A _3711_/A _3966_/A VPWR VGND sg13g2_nor2_1
X_3383_ _3385_/D _5310_/Q _3683_/A2 _3684_/B1 _5278_/Q VPWR VGND sg13g2_a22oi_1
X_5122_ _5122_/Y _5129_/A VPWR VGND sg13g2_inv_1
XFILLER_69_234 VPWR VGND sg13g2_fill_1
XFILLER_29_109 VPWR VGND sg13g2_fill_1
XFILLER_38_621 VPWR VGND sg13g2_decap_4
XFILLER_38_632 VPWR VGND sg13g2_decap_8
X_5053_ _5053_/Y _5150_/A VPWR VGND sg13g2_inv_1
XFILLER_57_429 VPWR VGND sg13g2_decap_8
XFILLER_37_142 VPWR VGND sg13g2_decap_8
XFILLER_38_643 VPWR VGND sg13g2_fill_1
X_4004_ _4004_/Y _4043_/B _4448_/C VPWR VGND sg13g2_nand2b_1
XFILLER_25_315 VPWR VGND sg13g2_decap_8
XFILLER_52_101 VPWR VGND sg13g2_fill_2
XFILLER_65_484 VPWR VGND sg13g2_decap_8
XFILLER_53_624 VPWR VGND sg13g2_fill_1
XFILLER_53_613 VPWR VGND sg13g2_fill_2
XFILLER_37_197 VPWR VGND sg13g2_decap_8
XFILLER_80_476 VPWR VGND sg13g2_fill_2
XFILLER_33_370 VPWR VGND sg13g2_fill_2
X_4906_ _4906_/Y _4889_/B _4896_/B _4904_/A VPWR VGND sg13g2_a21oi_1
X_4837_ _4844_/B _5216_/Q _4856_/C VPWR VGND sg13g2_nand2_1
X_4768_ _4768_/Y _4768_/A _4768_/B VPWR VGND sg13g2_xnor2_1
X_4699_ _4700_/C _4698_/B _4730_/A VPWR VGND sg13g2_nand2b_1
X_3719_ _3719_/Y _3721_/B _3721_/C VPWR VGND sg13g2_nor2_1
XFILLER_0_447 VPWR VGND sg13g2_fill_2
XFILLER_28_164 VPWR VGND sg13g2_decap_8
XFILLER_45_21 VPWR VGND sg13g2_decap_8
XFILLER_16_337 VPWR VGND sg13g2_decap_8
XFILLER_45_54 VPWR VGND sg13g2_decap_4
XFILLER_71_465 VPWR VGND sg13g2_decap_8
XFILLER_71_454 VPWR VGND sg13g2_fill_1
XFILLER_61_42 VPWR VGND sg13g2_decap_4
XFILLER_12_576 VPWR VGND sg13g2_decap_4
XFILLER_12_587 VPWR VGND sg13g2_fill_2
XFILLER_79_532 VPWR VGND sg13g2_fill_1
XFILLER_20_7 VPWR VGND sg13g2_fill_2
XFILLER_79_598 VPWR VGND sg13g2_decap_8
XFILLER_19_142 VPWR VGND sg13g2_decap_4
XFILLER_35_624 VPWR VGND sg13g2_decap_8
XFILLER_19_175 VPWR VGND sg13g2_fill_2
XFILLER_19_186 VPWR VGND sg13g2_decap_8
XFILLER_19_197 VPWR VGND sg13g2_fill_2
XFILLER_34_101 VPWR VGND sg13g2_decap_8
XFILLER_35_635 VPWR VGND sg13g2_fill_2
XFILLER_34_167 VPWR VGND sg13g2_fill_1
X_2952_ _3097_/B _3139_/A _3722_/B _3724_/C _3724_/B VPWR VGND sg13g2_a22oi_1
XFILLER_30_340 VPWR VGND sg13g2_decap_4
X_2883_ _2884_/A _2879_/Y _2881_/Y _2882_/Y VPWR VGND sg13g2_a21o_1
X_4622_ _4624_/A _3589_/A _4621_/A _4621_/Y VPWR VGND sg13g2_a21oi_1
X_4553_ _4555_/B _4706_/A _5445_/A _4556_/S VPWR VGND sg13g2_mux2_1
X_4484_ _5227_/D _2685_/Y _4480_/A _4483_/Y VPWR VGND sg13g2_o21ai_1
X_3504_ _3506_/B _3507_/B VPWR VGND sg13g2_inv_1
XFILLER_7_580 VPWR VGND sg13g2_decap_8
X_3435_ _3999_/B _3756_/A _3435_/B VPWR VGND sg13g2_xnor2_1
X_3366_ _3366_/Y _3365_/Y _3366_/B VPWR VGND sg13g2_nand2b_1
X_5105_ _5105_/Y _5175_/A VPWR VGND sg13g2_inv_1
X_3297_ _3298_/B _2986_/A _4209_/B1 _3233_/B _3027_/A VPWR VGND sg13g2_a22oi_1
XFILLER_57_226 VPWR VGND sg13g2_fill_1
X_5036_ _5036_/Y _5164_/A VPWR VGND sg13g2_inv_1
XFILLER_38_473 VPWR VGND sg13g2_decap_4
XFILLER_38_495 VPWR VGND sg13g2_decap_8
XFILLER_65_270 VPWR VGND sg13g2_fill_2
XFILLER_15_57 VPWR VGND sg13g2_decap_4
Xrebuffer600 _5441_/A _4568_/B VPWR VGND sg13g2_buf_1
Xrebuffer611 _5446_/A _4569_/B VPWR VGND sg13g2_buf_1
XFILLER_31_67 VPWR VGND sg13g2_fill_1
XFILLER_5_528 VPWR VGND sg13g2_decap_8
XFILLER_31_89 VPWR VGND sg13g2_decap_8
XFILLER_0_222 VPWR VGND sg13g2_decap_8
XFILLER_76_502 VPWR VGND sg13g2_decap_8
XFILLER_76_546 VPWR VGND sg13g2_fill_2
XFILLER_56_20 VPWR VGND sg13g2_decap_8
XFILLER_29_451 VPWR VGND sg13g2_decap_8
XFILLER_29_495 VPWR VGND sg13g2_fill_1
XFILLER_32_605 VPWR VGND sg13g2_decap_8
XFILLER_12_362 VPWR VGND sg13g2_decap_8
XFILLER_8_366 VPWR VGND sg13g2_decap_8
XFILLER_4_550 VPWR VGND sg13g2_decap_8
X_3220_ _3220_/Y _3244_/A1 _4471_/B _3219_/Y VPWR VGND sg13g2_a21oi_1
X_3151_ _4472_/A _3129_/Y _3138_/Y _3150_/Y VPWR VGND sg13g2_a21oi_1
X_3082_ _3085_/B _3413_/B _3236_/B1 _3233_/B _3773_/A VPWR VGND sg13g2_a22oi_1
XFILLER_35_465 VPWR VGND sg13g2_decap_8
XFILLER_50_413 VPWR VGND sg13g2_decap_8
X_3984_ _3985_/C _4041_/A _3984_/B _3984_/C VPWR VGND sg13g2_nand3_1
X_2935_ _2939_/A _5303_/Q _3548_/A2 _3004_/A2 _5335_/Q VPWR VGND sg13g2_a22oi_1
X_2866_ _2869_/A _3027_/B _3027_/C _2974_/B VPWR VGND sg13g2_o21ai_1
X_4605_ _4605_/X _5457_/A _4608_/C VPWR VGND sg13g2_xor2_1
X_2797_ _2917_/A _3166_/A _2799_/B VPWR VGND sg13g2_and2_1
X_4536_ _4536_/Y _4559_/B _5440_/A VPWR VGND sg13g2_nor2_1
X_4467_ _5229_/D _4460_/Y _4466_/Y _4458_/Y VPWR VGND sg13g2_a21oi_1
X_4398_ _5259_/D _3860_/Y hold678/X _4407_/S VPWR VGND sg13g2_mux2_1
X_3418_ _3418_/Y _4185_/C _3418_/B VPWR VGND sg13g2_nor2_1
X_3349_ _3353_/A _5193_/Q _3644_/B VPWR VGND sg13g2_nand2_1
XFILLER_45_218 VPWR VGND sg13g2_fill_1
X_5019_ _5019_/Y _5147_/A VPWR VGND sg13g2_inv_1
XFILLER_38_292 VPWR VGND sg13g2_decap_8
XFILLER_26_498 VPWR VGND sg13g2_decap_4
XFILLER_41_435 VPWR VGND sg13g2_fill_2
XFILLER_42_77 VPWR VGND sg13g2_decap_4
XFILLER_5_325 VPWR VGND sg13g2_decap_8
XFILLER_5_369 VPWR VGND sg13g2_decap_8
XFILLER_1_553 VPWR VGND sg13g2_decap_8
XFILLER_67_30 VPWR VGND sg13g2_decap_8
XFILLER_1_597 VPWR VGND sg13g2_decap_8
XFILLER_76_332 VPWR VGND sg13g2_fill_1
XFILLER_67_96 VPWR VGND sg13g2_decap_8
XFILLER_17_421 VPWR VGND sg13g2_decap_4
XFILLER_17_454 VPWR VGND sg13g2_fill_1
XFILLER_17_476 VPWR VGND sg13g2_fill_1
XFILLER_32_402 VPWR VGND sg13g2_decap_8
XFILLER_72_582 VPWR VGND sg13g2_decap_8
XFILLER_32_435 VPWR VGND sg13g2_decap_8
XFILLER_32_446 VPWR VGND sg13g2_fill_2
XFILLER_40_490 VPWR VGND sg13g2_decap_8
X_2720_ _2720_/Y _2723_/B _2722_/B VPWR VGND sg13g2_nor2_1
XFILLER_9_631 VPWR VGND sg13g2_decap_8
X_2651_ _3295_/A _3878_/A _4461_/A VPWR VGND sg13g2_nand2_1
XFILLER_8_141 VPWR VGND sg13g2_fill_1
X_5370_ _5370_/Q _5434_/CLK _5370_/D _5110_/Y VPWR VGND sg13g2_dfrbpq_1
X_2582_ _2582_/Y _2582_/A VPWR VGND sg13g2_inv_1
X_4321_ _5325_/D _3815_/Y hold819/X _4329_/S VPWR VGND sg13g2_mux2_1
X_4252_ _5378_/D hold751/X _4085_/Y _4258_/S VPWR VGND sg13g2_mux2_1
X_3203_ _3204_/B _3233_/A _3025_/B _3226_/A VPWR VGND sg13g2_a21oi_1
X_4183_ _4183_/Y _4441_/A _4183_/B VPWR VGND sg13g2_nand2_1
XFILLER_67_343 VPWR VGND sg13g2_decap_4
XFILLER_27_207 VPWR VGND sg13g2_decap_8
X_3134_ _3134_/X _3134_/A1 _4473_/B _3133_/Y VPWR VGND sg13g2_a21o_1
X_3065_ _3065_/Y _3889_/B _3065_/B VPWR VGND sg13g2_nand2b_1
XFILLER_67_398 VPWR VGND sg13g2_decap_8
XFILLER_70_508 VPWR VGND sg13g2_decap_8
XFILLER_23_413 VPWR VGND sg13g2_fill_2
XFILLER_23_435 VPWR VGND sg13g2_decap_8
XFILLER_35_284 VPWR VGND sg13g2_decap_8
X_3967_ _3968_/A _4069_/B2 _3771_/A _3711_/A _4068_/A _3966_/Y VPWR VGND sg13g2_a221oi_1
XFILLER_50_287 VPWR VGND sg13g2_fill_1
X_2918_ _3139_/A _2918_/A _2918_/B VPWR VGND sg13g2_nand2_1
XFILLER_31_490 VPWR VGND sg13g2_decap_8
X_3898_ _3898_/Y _3936_/A _3920_/A _4445_/B _4069_/B2 VPWR VGND sg13g2_a22oi_1
X_2849_ _2849_/Y _3275_/A _2850_/B VPWR VGND sg13g2_xnor2_1
X_4519_ _4519_/Y _2682_/B _2671_/B _2660_/B VPWR VGND sg13g2_a21oi_1
XFILLER_77_129 VPWR VGND sg13g2_decap_8
XFILLER_46_505 VPWR VGND sg13g2_fill_1
XFILLER_58_365 VPWR VGND sg13g2_decap_8
XFILLER_18_218 VPWR VGND sg13g2_decap_8
XFILLER_41_276 VPWR VGND sg13g2_decap_8
Xclkbuf_leaf_21_clk _5421_/CLK clkbuf_2_0__f_clk/X VPWR VGND sg13g2_buf_8
XFILLER_1_394 VPWR VGND sg13g2_fill_1
XFILLER_49_365 VPWR VGND sg13g2_fill_2
XFILLER_37_538 VPWR VGND sg13g2_decap_8
XFILLER_49_398 VPWR VGND sg13g2_decap_8
XFILLER_76_195 VPWR VGND sg13g2_decap_4
XFILLER_45_560 VPWR VGND sg13g2_fill_2
X_4870_ _4880_/B _4871_/B _4886_/B _4885_/A VPWR VGND sg13g2_a21oi_1
X_3821_ _3837_/A _3818_/X _3820_/Y _3829_/B VPWR VGND sg13g2_o21ai_1
XFILLER_60_574 VPWR VGND sg13g2_decap_8
Xclkbuf_leaf_12_clk _5434_/CLK clkbuf_2_3__f_clk/X VPWR VGND sg13g2_buf_8
X_3752_ _4093_/B _4160_/A _4116_/B _4143_/A _3752_/D VPWR VGND sg13g2_nor4_2
X_3683_ _3686_/B _5323_/Q _3683_/A2 _3683_/B1 _5355_/Q VPWR VGND sg13g2_a22oi_1
X_2703_ _2703_/X _2895_/D _2820_/B VPWR VGND sg13g2_and2_1
XFILLER_9_483 VPWR VGND sg13g2_fill_2
X_5422_ _5422_/Q clkload2/A _5422_/D _5162_/Y VPWR VGND sg13g2_dfrbpq_1
X_2634_ _2999_/A _4523_/A _2956_/B VPWR VGND sg13g2_nand2b_1
X_5353_ _5353_/Q clkload3/A _5353_/D _5093_/Y VPWR VGND sg13g2_dfrbpq_1
Xoutput202 io_wdata[14] _5450_/X VPWR VGND sg13g2_buf_1
Xoutput213 io_wdata[24] _5460_/X VPWR VGND sg13g2_buf_1
Xoutput224 io_wdata[5] _5441_/X VPWR VGND sg13g2_buf_1
X_2565_ _4485_/A _5229_/Q VPWR VGND sg13g2_inv_1
X_4304_ _4304_/Y _4304_/A _4312_/S VPWR VGND sg13g2_nand2_1
X_5284_ _5284_/Q clkload5/A _5284_/D _5024_/Y VPWR VGND sg13g2_dfrbpq_1
XFILLER_59_107 VPWR VGND sg13g2_decap_4
XFILLER_4_81 VPWR VGND sg13g2_decap_4
X_4235_ _5393_/D hold779/X _4278_/A _4235_/S VPWR VGND sg13g2_mux2_1
XFILLER_68_630 VPWR VGND sg13g2_decap_8
XFILLER_59_129 VPWR VGND sg13g2_decap_8
XFILLER_28_505 VPWR VGND sg13g2_fill_2
X_4166_ _4168_/C _4208_/A _3721_/C _4165_/Y VPWR VGND sg13g2_o21ai_1
XFILLER_67_151 VPWR VGND sg13g2_decap_8
X_3117_ _3127_/A _4159_/A _3117_/B _3117_/C VPWR VGND sg13g2_nor3_1
X_4097_ _4099_/C _3847_/A _3507_/A _4448_/D _4459_/A1 _4096_/Y VPWR VGND sg13g2_a221oi_1
X_3048_ _3409_/B _3131_/A _3048_/B VPWR VGND sg13g2_nand2_1
XFILLER_23_46 VPWR VGND sg13g2_decap_4
X_4999_ _4999_/Y _5095_/A VPWR VGND sg13g2_inv_1
XFILLER_23_57 VPWR VGND sg13g2_fill_2
Xfanout440 _3399_/B1 _2722_/Y VPWR VGND sg13g2_buf_1
Xfanout451 _3676_/A2 _3687_/B VPWR VGND sg13g2_buf_1
Xfanout462 _3004_/B1 _2703_/X VPWR VGND sg13g2_buf_1
Xfanout473 _3492_/B _3547_/B1 VPWR VGND sg13g2_buf_1
Xfanout484 _3896_/A _4094_/B1 VPWR VGND sg13g2_buf_1
XFILLER_74_600 VPWR VGND sg13g2_decap_4
Xfanout495 _4159_/A _2646_/Y VPWR VGND sg13g2_buf_1
XFILLER_74_611 VPWR VGND sg13g2_decap_4
XFILLER_0_39 VPWR VGND sg13g2_decap_8
XFILLER_34_508 VPWR VGND sg13g2_decap_8
XFILLER_61_327 VPWR VGND sg13g2_decap_8
XFILLER_14_287 VPWR VGND sg13g2_fill_2
XFILLER_9_48 VPWR VGND sg13g2_fill_1
XFILLER_10_493 VPWR VGND sg13g2_fill_1
XFILLER_6_464 VPWR VGND sg13g2_decap_8
Xclkbuf_leaf_1_clk clkload6/A clkbuf_leaf_3_clk/A VPWR VGND sg13g2_buf_8
X_4020_ _4025_/A _4020_/A _4030_/A VPWR VGND sg13g2_nor2_1
XFILLER_77_471 VPWR VGND sg13g2_decap_4
XFILLER_64_121 VPWR VGND sg13g2_decap_8
XFILLER_25_519 VPWR VGND sg13g2_decap_8
XFILLER_52_338 VPWR VGND sg13g2_fill_1
X_4922_ _4922_/Y _5150_/A VPWR VGND sg13g2_inv_1
XFILLER_33_563 VPWR VGND sg13g2_decap_8
X_4853_ _4853_/Y _4878_/A _4853_/B VPWR VGND sg13g2_nand2_1
XFILLER_60_382 VPWR VGND sg13g2_decap_8
X_4784_ _4808_/B _4831_/A _4784_/B VPWR VGND sg13g2_xnor2_1
X_3804_ _3810_/A _3921_/A _3804_/B VPWR VGND sg13g2_nor2_1
X_3735_ _3945_/B _3730_/Y _3733_/Y _3734_/Y VPWR VGND sg13g2_o21ai_1
X_5405_ _5405_/Q _5426_/CLK _5405_/D _5145_/Y VPWR VGND sg13g2_dfrbpq_1
X_3666_ _3670_/A _5324_/Q _3666_/B VPWR VGND sg13g2_nand2_1
X_3597_ _3660_/B _3679_/A _4621_/B _3589_/Y VPWR VGND sg13g2_o21ai_1
X_2617_ _2617_/Y _2617_/A VPWR VGND sg13g2_inv_1
X_5336_ _5336_/Q _5432_/CLK _5336_/D _5076_/Y VPWR VGND sg13g2_dfrbpq_1
X_2548_ _3368_/A _2548_/A VPWR VGND sg13g2_inv_1
X_5267_ _5267_/Q _5427_/CLK _5267_/D _5007_/Y VPWR VGND sg13g2_dfrbpq_1
X_4218_ _4218_/Y _2573_/A _4218_/A2 _4219_/A2 VPWR VGND sg13g2_a21oi_1
X_5198_ _5198_/Q _5206_/CLK _5198_/D _4938_/Y VPWR VGND sg13g2_dfrbpq_1
X_4149_ _4335_/A _2600_/Y _4178_/A2 _4147_/Y _4148_/Y VPWR VGND sg13g2_a22oi_1
XFILLER_43_305 VPWR VGND sg13g2_fill_1
XFILLER_70_168 VPWR VGND sg13g2_fill_1
XFILLER_24_596 VPWR VGND sg13g2_fill_1
XFILLER_11_268 VPWR VGND sg13g2_decap_8
XFILLER_50_11 VPWR VGND sg13g2_fill_2
Xclkload0 clkload0/Y clkload0/A VPWR VGND sg13g2_inv_8
XFILLER_59_86 VPWR VGND sg13g2_decap_4
XFILLER_59_53 VPWR VGND sg13g2_decap_8
XFILLER_47_611 VPWR VGND sg13g2_decap_8
Xfanout270 _3269_/B _4171_/B1 VPWR VGND sg13g2_buf_1
Xfanout281 _4131_/A _3057_/Y VPWR VGND sg13g2_buf_1
Xfanout292 _4664_/A _4691_/A VPWR VGND sg13g2_buf_1
XFILLER_75_30 VPWR VGND sg13g2_decap_8
XFILLER_46_132 VPWR VGND sg13g2_decap_8
XFILLER_34_305 VPWR VGND sg13g2_decap_8
XFILLER_46_165 VPWR VGND sg13g2_fill_2
XFILLER_15_541 VPWR VGND sg13g2_decap_8
XFILLER_61_179 VPWR VGND sg13g2_decap_4
X_3520_ _5454_/A _3520_/A _3520_/B _3520_/C _3520_/D VPWR VGND sg13g2_nand4_1
XFILLER_10_290 VPWR VGND sg13g2_fill_1
Xhold707 hold707/X _5176_/Q VPWR VGND sg13g2_dlygate4sd3_1
Xhold718 hold718/X _5313_/Q VPWR VGND sg13g2_dlygate4sd3_1
Xhold729 hold729/X _5337_/Q VPWR VGND sg13g2_dlygate4sd3_1
X_3451_ _3966_/A _3936_/B _3453_/B VPWR VGND sg13g2_nor2_1
XFILLER_6_283 VPWR VGND sg13g2_decap_8
X_3382_ _3385_/C _5374_/Q _3492_/B _3683_/B1 _5342_/Q VPWR VGND sg13g2_a22oi_1
X_5121_ _5121_/Y _5160_/A VPWR VGND sg13g2_inv_1
X_5052_ _5052_/Y _5092_/A VPWR VGND sg13g2_inv_1
XFILLER_69_279 VPWR VGND sg13g2_fill_2
XFILLER_37_110 VPWR VGND sg13g2_decap_8
XFILLER_37_121 VPWR VGND sg13g2_decap_8
X_4003_ _4003_/Y _3997_/Y _4003_/B _4003_/C VPWR VGND sg13g2_nand3b_1
XFILLER_65_463 VPWR VGND sg13g2_decap_8
XFILLER_25_349 VPWR VGND sg13g2_decap_8
XFILLER_21_511 VPWR VGND sg13g2_decap_8
XFILLER_33_382 VPWR VGND sg13g2_decap_8
X_4905_ _4905_/Y _4905_/A _4905_/B VPWR VGND sg13g2_nor2_1
X_4836_ _5215_/D _4833_/X _4835_/Y _4829_/Y VPWR VGND sg13g2_o21ai_1
X_4767_ _4768_/B _4756_/B _4756_/C _4750_/Y VPWR VGND sg13g2_a21o_1
X_4698_ _4700_/B _4730_/A _4698_/B VPWR VGND sg13g2_nand2b_1
X_3718_ _4040_/B _3718_/A VPWR VGND sg13g2_inv_1
X_3649_ _3649_/Y _5257_/Q _2724_/A _3692_/A2 VPWR VGND sg13g2_a21oi_1
X_5319_ _5319_/Q clkload1/A _5319_/D _5059_/Y VPWR VGND sg13g2_dfrbpq_1
XFILLER_29_611 VPWR VGND sg13g2_fill_2
XFILLER_29_89 VPWR VGND sg13g2_decap_8
XFILLER_28_154 VPWR VGND sg13g2_fill_1
XFILLER_44_603 VPWR VGND sg13g2_fill_2
XFILLER_56_463 VPWR VGND sg13g2_decap_8
XFILLER_56_496 VPWR VGND sg13g2_decap_4
XFILLER_45_77 VPWR VGND sg13g2_fill_2
XFILLER_8_504 VPWR VGND sg13g2_fill_1
XFILLER_61_87 VPWR VGND sg13g2_decap_8
XFILLER_6_49 VPWR VGND sg13g2_decap_8
XFILLER_19_132 VPWR VGND sg13g2_fill_1
XFILLER_47_430 VPWR VGND sg13g2_fill_1
XFILLER_62_400 VPWR VGND sg13g2_decap_8
XFILLER_62_466 VPWR VGND sg13g2_decap_4
X_2951_ _3724_/C _2951_/A _2951_/B VPWR VGND sg13g2_or2_1
XFILLER_62_488 VPWR VGND sg13g2_decap_8
XFILLER_30_363 VPWR VGND sg13g2_decap_8
X_4621_ _4621_/Y _4621_/A _4621_/B _4621_/C VPWR VGND sg13g2_nor3_1
X_2882_ _2882_/Y _5231_/Q _3401_/A2 _3398_/B1 VPWR VGND sg13g2_a21oi_1
X_4552_ _4552_/Y _4551_/B _4550_/Y _4555_/A VPWR VGND sg13g2_o21ai_1
X_4483_ _4483_/Y _4483_/A _4483_/B VPWR VGND sg13g2_nand2_1
X_3503_ _3507_/B _4318_/A _5455_/A _3634_/A VPWR VGND sg13g2_mux2_1
X_3434_ _3983_/A _3756_/A _3435_/B VPWR VGND sg13g2_nand2_1
X_3365_ _3365_/Y _5245_/Q _3365_/A2 _3365_/B1 VPWR VGND sg13g2_a21oi_1
X_5104_ _5104_/Y _5175_/A VPWR VGND sg13g2_inv_1
X_3296_ _3298_/A _4188_/B2 _2869_/B _3294_/Y _3295_/X VPWR VGND sg13g2_a22oi_1
X_5035_ _5035_/Y _5132_/A VPWR VGND sg13g2_inv_1
XFILLER_72_219 VPWR VGND sg13g2_decap_8
XFILLER_15_14 VPWR VGND sg13g2_decap_8
XFILLER_53_444 VPWR VGND sg13g2_decap_8
XFILLER_25_168 VPWR VGND sg13g2_decap_8
XFILLER_21_330 VPWR VGND sg13g2_decap_8
XFILLER_33_190 VPWR VGND sg13g2_decap_8
XFILLER_21_341 VPWR VGND sg13g2_fill_1
XFILLER_31_35 VPWR VGND sg13g2_decap_8
Xrebuffer601 _5447_/A _4569_/A VPWR VGND sg13g2_buf_1
Xrebuffer612 _4581_/B _4584_/C VPWR VGND sg13g2_buf_1
X_4819_ _4848_/B _4831_/A _4820_/B VPWR VGND sg13g2_or2_1
XFILLER_31_79 VPWR VGND sg13g2_decap_4
XFILLER_0_201 VPWR VGND sg13g2_decap_8
XFILLER_0_245 VPWR VGND sg13g2_fill_2
XFILLER_76_569 VPWR VGND sg13g2_decap_8
XFILLER_16_113 VPWR VGND sg13g2_decap_4
XFILLER_56_76 VPWR VGND sg13g2_decap_8
XFILLER_44_433 VPWR VGND sg13g2_decap_8
XFILLER_44_466 VPWR VGND sg13g2_decap_8
XFILLER_16_179 VPWR VGND sg13g2_decap_8
XFILLER_72_53 VPWR VGND sg13g2_decap_4
XFILLER_31_149 VPWR VGND sg13g2_decap_8
XFILLER_4_595 VPWR VGND sg13g2_decap_8
X_3150_ _3150_/Y _4111_/A _3139_/Y _3149_/Y VPWR VGND sg13g2_o21ai_1
X_3081_ _3081_/Y _4208_/A _3081_/B VPWR VGND sg13g2_nor2_1
XFILLER_67_558 VPWR VGND sg13g2_fill_2
XFILLER_47_271 VPWR VGND sg13g2_decap_4
XFILLER_35_444 VPWR VGND sg13g2_decap_8
XFILLER_23_639 VPWR VGND sg13g2_decap_4
XFILLER_35_488 VPWR VGND sg13g2_decap_8
XFILLER_62_252 VPWR VGND sg13g2_decap_8
X_3983_ _3984_/C _3983_/A _3983_/B _3983_/C VPWR VGND sg13g2_nand3_1
XFILLER_15_190 VPWR VGND sg13g2_decap_8
X_2934_ _3131_/A _2993_/A _3022_/B VPWR VGND sg13g2_xnor2_1
XFILLER_30_182 VPWR VGND sg13g2_fill_1
X_2865_ _3027_/C _2656_/A _2656_/B _2860_/Y _2862_/Y _2863_/Y VPWR VGND sg13g2_a221oi_1
X_4604_ _4604_/Y _4623_/C _4602_/Y _4603_/Y VPWR VGND sg13g2_o21ai_1
X_4535_ _4539_/B _5440_/A _4535_/B VPWR VGND sg13g2_or2_1
X_2796_ _2796_/Y _2796_/A _2799_/B VPWR VGND sg13g2_nor2_1
X_4466_ _4466_/Y _4466_/A _4466_/B _4466_/C VPWR VGND sg13g2_nor3_1
X_4397_ _5260_/D _3840_/Y hold685/X _4407_/S VPWR VGND sg13g2_mux2_1
X_3417_ _4172_/A _4162_/B _3417_/B VPWR VGND sg13g2_nor2_1
X_3348_ _4448_/A _3764_/A VPWR VGND sg13g2_inv_1
XFILLER_58_514 VPWR VGND sg13g2_fill_1
XFILLER_58_536 VPWR VGND sg13g2_fill_2
X_3279_ _3281_/C _4188_/A1 _2848_/X _3232_/C _3274_/Y _3278_/X VPWR VGND sg13g2_a221oi_1
X_5018_ _5018_/Y _5148_/A VPWR VGND sg13g2_inv_1
XFILLER_73_528 VPWR VGND sg13g2_decap_8
XFILLER_66_580 VPWR VGND sg13g2_decap_8
XFILLER_26_466 VPWR VGND sg13g2_fill_1
XFILLER_41_414 VPWR VGND sg13g2_decap_8
XFILLER_81_583 VPWR VGND sg13g2_decap_8
XFILLER_42_56 VPWR VGND sg13g2_decap_8
XFILLER_1_532 VPWR VGND sg13g2_decap_8
XFILLER_3_28 VPWR VGND sg13g2_fill_2
Xhold890 _2628_/A _5208_/Q VPWR VGND sg13g2_dlygate4sd3_1
XFILLER_1_565 VPWR VGND sg13g2_fill_1
XFILLER_1_576 VPWR VGND sg13g2_decap_8
XFILLER_49_536 VPWR VGND sg13g2_decap_8
XFILLER_76_311 VPWR VGND sg13g2_decap_8
XFILLER_67_75 VPWR VGND sg13g2_decap_8
XFILLER_57_591 VPWR VGND sg13g2_decap_8
XFILLER_17_499 VPWR VGND sg13g2_decap_8
XFILLER_8_120 VPWR VGND sg13g2_decap_8
X_2650_ _3254_/A _2682_/B _3000_/B _2671_/B VPWR VGND sg13g2_nand3_1
X_2581_ _2581_/Y _2581_/A VPWR VGND sg13g2_inv_1
XFILLER_59_4 VPWR VGND sg13g2_decap_8
X_4320_ _5326_/D _3796_/Y hold823/X _4329_/S VPWR VGND sg13g2_mux2_1
XFILLER_4_381 VPWR VGND sg13g2_decap_8
X_4251_ _5379_/D hold753/X _4059_/Y _4258_/S VPWR VGND sg13g2_mux2_1
X_3202_ _3202_/Y _4131_/A _3202_/B VPWR VGND sg13g2_nor2_1
X_4182_ _4183_/B _4438_/A _4204_/B _4158_/B VPWR VGND sg13g2_a21oi_1
X_3133_ _3133_/Y input96/X _3134_/A1 _3065_/B VPWR VGND sg13g2_o21ai_1
X_3064_ _3064_/Y _3064_/A _3889_/B VPWR VGND sg13g2_nor2_1
XFILLER_35_252 VPWR VGND sg13g2_fill_1
XFILLER_35_263 VPWR VGND sg13g2_decap_4
XFILLER_50_266 VPWR VGND sg13g2_fill_2
X_3966_ _3966_/Y _3966_/A _3966_/B VPWR VGND sg13g2_nor2_1
XFILLER_31_480 VPWR VGND sg13g2_decap_4
XFILLER_50_277 VPWR VGND sg13g2_fill_2
X_2917_ _2918_/B _2917_/A _2917_/B _2917_/C VPWR VGND sg13g2_nor3_1
X_3897_ _3901_/B _4001_/B2 _3636_/A _3642_/Y _3938_/A VPWR VGND sg13g2_a22oi_1
X_2848_ _2848_/X _2986_/A _2850_/B VPWR VGND sg13g2_and2_1
X_2779_ _2916_/A _3187_/A _3040_/A VPWR VGND sg13g2_nand2_1
X_4518_ _5176_/D hold707/X _4261_/A _4518_/S VPWR VGND sg13g2_mux2_1
X_4449_ _4451_/C _4449_/A _4449_/B _4449_/C _4452_/A VPWR VGND sg13g2_nor4_1
XFILLER_58_344 VPWR VGND sg13g2_decap_8
XFILLER_37_78 VPWR VGND sg13g2_decap_8
XFILLER_41_222 VPWR VGND sg13g2_decap_4
XFILLER_53_44 VPWR VGND sg13g2_decap_8
XFILLER_14_469 VPWR VGND sg13g2_decap_8
XFILLER_10_642 VPWR VGND sg13g2_decap_8
XFILLER_5_145 VPWR VGND sg13g2_decap_8
XFILLER_5_123 VPWR VGND sg13g2_decap_8
XFILLER_5_167 VPWR VGND sg13g2_decap_8
XFILLER_78_52 VPWR VGND sg13g2_decap_8
XFILLER_68_119 VPWR VGND sg13g2_decap_8
XFILLER_78_96 VPWR VGND sg13g2_fill_2
XFILLER_77_631 VPWR VGND sg13g2_decap_4
XFILLER_64_347 VPWR VGND sg13g2_decap_8
XFILLER_45_550 VPWR VGND sg13g2_fill_2
XFILLER_72_380 VPWR VGND sg13g2_decap_8
XFILLER_32_255 VPWR VGND sg13g2_decap_8
X_3820_ _3820_/Y _3856_/A _3820_/B _3856_/B VPWR VGND sg13g2_nor3_1
XFILLER_60_553 VPWR VGND sg13g2_decap_8
XFILLER_20_417 VPWR VGND sg13g2_decap_8
X_3751_ _4115_/B _4160_/A _4143_/A _3752_/D VPWR VGND sg13g2_nor3_1
X_2702_ _2820_/B _2895_/C _2895_/B VPWR VGND sg13g2_nor2b_1
XFILLER_9_462 VPWR VGND sg13g2_decap_8
X_3682_ _3686_/A _5387_/Q _3492_/B _3682_/B1 _5419_/Q VPWR VGND sg13g2_a22oi_1
X_5421_ _5421_/Q _5421_/CLK _5421_/D _5161_/Y VPWR VGND sg13g2_dfrbpq_1
X_2633_ _3000_/A _4489_/B _4490_/A VPWR VGND sg13g2_nor2_1
X_5352_ _5352_/Q clkload8/A _5352_/D _5092_/Y VPWR VGND sg13g2_dfrbpq_1
Xoutput203 io_wdata[15] _5451_/X VPWR VGND sg13g2_buf_1
Xoutput214 io_wdata[25] _5461_/X VPWR VGND sg13g2_buf_1
Xoutput225 io_wdata[6] _5442_/X VPWR VGND sg13g2_buf_1
X_2564_ _2564_/Y _2564_/A VPWR VGND sg13g2_inv_1
X_4303_ _5340_/D _4261_/A hold711/X _4317_/S VPWR VGND sg13g2_mux2_1
X_5283_ _5283_/Q _5414_/CLK _5283_/D _5023_/Y VPWR VGND sg13g2_dfrbpq_1
X_4234_ _5394_/D _2826_/A _4236_/S _4233_/Y VPWR VGND sg13g2_o21ai_1
XFILLER_68_620 VPWR VGND sg13g2_decap_8
X_4165_ _4165_/Y _3233_/B _4185_/C _3393_/X _4188_/A1 _4162_/Y VPWR VGND sg13g2_a221oi_1
X_3116_ _3117_/C _3205_/B _2981_/D _4439_/C VPWR VGND sg13g2_a21oi_1
X_4096_ _4096_/Y _4116_/A _4096_/B VPWR VGND sg13g2_nor2_1
XFILLER_43_509 VPWR VGND sg13g2_fill_1
X_3047_ _3047_/X _3131_/A _3048_/B VPWR VGND sg13g2_and2_1
XFILLER_23_233 VPWR VGND sg13g2_decap_8
XFILLER_23_244 VPWR VGND sg13g2_fill_1
XFILLER_11_417 VPWR VGND sg13g2_decap_8
X_4998_ _4998_/Y _5001_/A VPWR VGND sg13g2_inv_1
X_3949_ _4477_/B _3949_/A _3949_/B VPWR VGND sg13g2_or2_1
XFILLER_3_638 VPWR VGND sg13g2_decap_8
XFILLER_48_11 VPWR VGND sg13g2_fill_2
Xfanout430 _4211_/A2 _2999_/Y VPWR VGND sg13g2_buf_1
Xfanout441 _3674_/B1 _3688_/B1 VPWR VGND sg13g2_buf_1
XFILLER_48_66 VPWR VGND sg13g2_decap_8
Xfanout452 _3687_/B _2927_/A2 VPWR VGND sg13g2_buf_1
Xfanout463 _3668_/A2 _3683_/B1 VPWR VGND sg13g2_buf_1
Xfanout474 _3003_/A2 _3547_/B1 VPWR VGND sg13g2_buf_1
Xfanout485 _4188_/B2 _4094_/B1 VPWR VGND sg13g2_buf_1
Xfanout496 _4043_/A _4074_/A1 VPWR VGND sg13g2_buf_1
XFILLER_0_18 VPWR VGND sg13g2_decap_8
XFILLER_73_133 VPWR VGND sg13g2_decap_8
XFILLER_27_572 VPWR VGND sg13g2_decap_8
XFILLER_61_306 VPWR VGND sg13g2_decap_8
XFILLER_27_594 VPWR VGND sg13g2_decap_8
XFILLER_42_520 VPWR VGND sg13g2_fill_2
XFILLER_42_531 VPWR VGND sg13g2_decap_8
XFILLER_14_266 VPWR VGND sg13g2_decap_4
XFILLER_80_97 VPWR VGND sg13g2_decap_4
XFILLER_80_86 VPWR VGND sg13g2_fill_2
XFILLER_13_80 VPWR VGND sg13g2_decap_8
XFILLER_13_91 VPWR VGND sg13g2_fill_1
XFILLER_6_498 VPWR VGND sg13g2_decap_8
XFILLER_77_450 VPWR VGND sg13g2_decap_8
XFILLER_65_623 VPWR VGND sg13g2_fill_2
XFILLER_65_612 VPWR VGND sg13g2_decap_8
XFILLER_37_325 VPWR VGND sg13g2_decap_4
XFILLER_37_336 VPWR VGND sg13g2_decap_8
XFILLER_64_155 VPWR VGND sg13g2_decap_8
XFILLER_18_594 VPWR VGND sg13g2_decap_8
XFILLER_52_328 VPWR VGND sg13g2_fill_2
X_4921_ _4921_/Y _5134_/A VPWR VGND sg13g2_inv_1
XFILLER_64_199 VPWR VGND sg13g2_decap_8
X_4852_ _4853_/B _4852_/A _4867_/A VPWR VGND sg13g2_xor2_1
X_3803_ _3804_/B _3803_/A _3803_/B VPWR VGND sg13g2_and2_1
XFILLER_60_372 VPWR VGND sg13g2_fill_2
X_4783_ _4785_/A _4783_/A _4793_/A VPWR VGND sg13g2_nor2b_1
X_3734_ _3734_/Y _3733_/A _3718_/A _3712_/Y VPWR VGND sg13g2_a21oi_1
X_3665_ _3855_/A _3636_/A _3879_/C _3657_/Y _3893_/A _3664_/Y VPWR VGND sg13g2_a221oi_1
X_5404_ _5404_/Q _5434_/CLK _5404_/D _5144_/Y VPWR VGND sg13g2_dfrbpq_1
X_2616_ _2616_/Y _2616_/A VPWR VGND sg13g2_inv_1
X_3596_ _5461_/A _4621_/B VPWR VGND sg13g2_inv_1
XFILLER_0_619 VPWR VGND sg13g2_decap_8
X_5335_ _5335_/Q _5425_/CLK _5335_/D _5075_/Y VPWR VGND sg13g2_dfrbpq_1
X_2547_ _3386_/A _5374_/Q VPWR VGND sg13g2_inv_1
X_5266_ _5266_/Q _5426_/CLK _5266_/D _5006_/Y VPWR VGND sg13g2_dfrbpq_1
X_4217_ _4217_/Y _4217_/A1 _4476_/C _4216_/Y VPWR VGND sg13g2_o21ai_1
X_5197_ _5197_/Q _5206_/CLK _5197_/D _4937_/Y VPWR VGND sg13g2_dfrbpq_1
X_4148_ _4148_/Y input40/X _2666_/C _4178_/A2 VPWR VGND sg13g2_a21oi_1
XFILLER_16_509 VPWR VGND sg13g2_fill_1
X_4079_ _4079_/Y _3714_/A _4078_/X _4431_/B1 VPWR VGND sg13g2_o21ai_1
XFILLER_43_328 VPWR VGND sg13g2_decap_8
XFILLER_55_199 VPWR VGND sg13g2_fill_2
XFILLER_34_35 VPWR VGND sg13g2_decap_8
XFILLER_24_575 VPWR VGND sg13g2_fill_1
XFILLER_50_23 VPWR VGND sg13g2_decap_4
Xclkload1 clkload1/Y clkload1/A VPWR VGND sg13g2_inv_2
XFILLER_50_78 VPWR VGND sg13g2_decap_8
XFILLER_78_247 VPWR VGND sg13g2_fill_2
XFILLER_66_409 VPWR VGND sg13g2_decap_8
XFILLER_46_100 VPWR VGND sg13g2_decap_8
Xfanout260 _4179_/S _4235_/S VPWR VGND sg13g2_buf_1
Xfanout271 _4171_/B1 _3056_/Y VPWR VGND sg13g2_buf_1
Xfanout282 _4438_/A _3366_/Y VPWR VGND sg13g2_buf_1
XFILLER_59_450 VPWR VGND sg13g2_fill_1
XFILLER_46_111 VPWR VGND sg13g2_fill_1
Xfanout293 _4691_/A _4701_/A1 VPWR VGND sg13g2_buf_1
XFILLER_75_64 VPWR VGND sg13g2_fill_1
XFILLER_75_53 VPWR VGND sg13g2_fill_2
XFILLER_19_358 VPWR VGND sg13g2_decap_8
XFILLER_15_520 VPWR VGND sg13g2_decap_8
XFILLER_46_188 VPWR VGND sg13g2_fill_1
XFILLER_62_626 VPWR VGND sg13g2_fill_2
XFILLER_61_103 VPWR VGND sg13g2_decap_4
XFILLER_61_158 VPWR VGND sg13g2_decap_8
XFILLER_61_147 VPWR VGND sg13g2_fill_2
XFILLER_30_556 VPWR VGND sg13g2_fill_1
Xhold708 hold708/X _5421_/Q VPWR VGND sg13g2_dlygate4sd3_1
Xhold719 hold719/X _5188_/Q VPWR VGND sg13g2_dlygate4sd3_1
XFILLER_6_251 VPWR VGND sg13g2_decap_8
X_3450_ _3711_/A _3936_/B _3453_/B VPWR VGND sg13g2_and2_1
X_3381_ _3385_/B _5178_/Q _3456_/B _3508_/B _5406_/Q VPWR VGND sg13g2_a22oi_1
X_5120_ _5120_/Y _5152_/A VPWR VGND sg13g2_inv_1
X_5051_ _5051_/Y _5149_/A VPWR VGND sg13g2_inv_1
XFILLER_69_258 VPWR VGND sg13g2_decap_8
X_4002_ _4003_/C _4069_/B2 _3427_/Y _4448_/C _3936_/A _3999_/Y VPWR VGND sg13g2_a221oi_1
XFILLER_65_442 VPWR VGND sg13g2_decap_4
XFILLER_25_328 VPWR VGND sg13g2_decap_8
XFILLER_52_103 VPWR VGND sg13g2_fill_1
XFILLER_80_423 VPWR VGND sg13g2_fill_1
XFILLER_18_391 VPWR VGND sg13g2_decap_8
X_4904_ _4904_/Y _4904_/A _4904_/B VPWR VGND sg13g2_xnor2_1
X_4835_ _4835_/Y _4834_/Y _4839_/A VPWR VGND sg13g2_nand2b_1
X_4766_ _4768_/A _4766_/A VPWR VGND sg13g2_inv_1
X_3717_ _3718_/A _3731_/C _3715_/X _3716_/Y VPWR VGND sg13g2_o21ai_1
X_4697_ _4730_/A _4697_/A _4697_/B VPWR VGND sg13g2_xnor2_1
XFILLER_20_59 VPWR VGND sg13g2_decap_8
X_3648_ _3650_/B _3648_/A _3648_/B _3648_/C VPWR VGND sg13g2_nand3_1
X_3579_ _3580_/B _3564_/A _3573_/X _3991_/B _3455_/Y _3578_/Y VPWR VGND sg13g2_a221oi_1
X_5318_ _5318_/Q clkload1/A _5318_/D _5058_/Y VPWR VGND sg13g2_dfrbpq_1
XFILLER_0_449 VPWR VGND sg13g2_fill_1
XFILLER_29_68 VPWR VGND sg13g2_decap_8
X_5249_ _5249_/Q clkload7/A _5249_/D _4989_/Y VPWR VGND sg13g2_dfrbpq_1
XFILLER_68_280 VPWR VGND sg13g2_decap_8
XFILLER_71_423 VPWR VGND sg13g2_decap_8
XFILLER_71_445 VPWR VGND sg13g2_decap_8
XFILLER_31_309 VPWR VGND sg13g2_decap_8
XFILLER_12_534 VPWR VGND sg13g2_fill_2
XFILLER_12_589 VPWR VGND sg13g2_fill_1
XFILLER_8_527 VPWR VGND sg13g2_decap_8
XFILLER_61_66 VPWR VGND sg13g2_decap_8
XFILLER_8_549 VPWR VGND sg13g2_fill_2
XFILLER_10_81 VPWR VGND sg13g2_decap_8
XFILLER_79_523 VPWR VGND sg13g2_fill_1
XFILLER_79_567 VPWR VGND sg13g2_fill_1
XFILLER_47_464 VPWR VGND sg13g2_decap_8
XFILLER_47_497 VPWR VGND sg13g2_decap_8
XFILLER_62_445 VPWR VGND sg13g2_decap_8
X_2950_ _3722_/B _3131_/A _3048_/B VPWR VGND sg13g2_nor2_1
XFILLER_15_394 VPWR VGND sg13g2_decap_8
XFILLER_42_191 VPWR VGND sg13g2_fill_2
X_2881_ _2881_/Y _5263_/Q _3400_/A2 _3400_/B1 _5327_/Q _2880_/Y VPWR VGND sg13g2_a221oi_1
X_4620_ _4620_/Y _4621_/C _4620_/B _4620_/C VPWR VGND sg13g2_nand3b_1
X_4551_ _4555_/A _5444_/A _4551_/B VPWR VGND sg13g2_nand2b_1
XFILLER_7_560 VPWR VGND sg13g2_fill_1
X_4482_ _5228_/D _4480_/Y _4481_/X _4468_/Y VPWR VGND sg13g2_o21ai_1
X_3502_ _5455_/A _3502_/A _3502_/B _3502_/C _3502_/D VPWR VGND sg13g2_nand4_1
X_3433_ _3435_/B _2716_/C _5458_/A _3634_/A VPWR VGND sg13g2_mux2_1
XFILLER_32_0 VPWR VGND sg13g2_fill_2
X_5103_ _5103_/Y _5167_/A VPWR VGND sg13g2_inv_1
X_3364_ _3366_/B _3364_/A _3364_/B _3364_/C VPWR VGND sg13g2_nand3_1
X_3295_ _3295_/X _3295_/A _3295_/B VPWR VGND sg13g2_or2_1
X_5034_ _5034_/Y _5158_/A VPWR VGND sg13g2_inv_1
XFILLER_38_464 VPWR VGND sg13g2_decap_4
XFILLER_65_283 VPWR VGND sg13g2_decap_4
XFILLER_53_423 VPWR VGND sg13g2_decap_8
XFILLER_25_147 VPWR VGND sg13g2_decap_8
XFILLER_40_128 VPWR VGND sg13g2_decap_8
Xrebuffer602 _5445_/A _4566_/C VPWR VGND sg13g2_buf_1
X_4818_ _4820_/B hold851/X _4828_/B VPWR VGND sg13g2_nand2b_1
X_4749_ _4756_/A _4749_/A _4761_/B _4749_/C VPWR VGND sg13g2_nand3_1
XFILLER_76_548 VPWR VGND sg13g2_fill_1
XFILLER_56_66 VPWR VGND sg13g2_fill_1
XFILLER_56_55 VPWR VGND sg13g2_decap_8
XFILLER_56_283 VPWR VGND sg13g2_decap_8
XFILLER_16_147 VPWR VGND sg13g2_fill_2
XFILLER_24_180 VPWR VGND sg13g2_decap_4
XFILLER_12_386 VPWR VGND sg13g2_decap_8
XFILLER_4_574 VPWR VGND sg13g2_decap_8
XFILLER_79_342 VPWR VGND sg13g2_decap_4
X_3080_ _3085_/A _3120_/A _3086_/B VPWR VGND sg13g2_nand2_1
XFILLER_67_537 VPWR VGND sg13g2_decap_8
XFILLER_35_412 VPWR VGND sg13g2_decap_8
XFILLER_47_250 VPWR VGND sg13g2_decap_8
X_3982_ _3984_/B _3983_/A _3983_/C _3983_/B VPWR VGND sg13g2_a21o_1
XFILLER_22_117 VPWR VGND sg13g2_decap_8
XFILLER_50_448 VPWR VGND sg13g2_decap_8
X_2933_ _3724_/B _2993_/A _3022_/B VPWR VGND sg13g2_or2_1
XFILLER_30_161 VPWR VGND sg13g2_fill_1
X_2864_ _5437_/A _2860_/Y _2862_/Y _2863_/Y VPWR VGND sg13g2_a21oi_1
X_4603_ _4603_/Y _4603_/A1 _4621_/A _5456_/A _4618_/B2 VPWR VGND sg13g2_a22oi_1
X_2795_ _2799_/B _4688_/A _5443_/A _3403_/S VPWR VGND sg13g2_mux2_1
X_4534_ _4534_/Y _4532_/Y _4533_/Y _4535_/B VPWR VGND sg13g2_o21ai_1
X_4465_ _4466_/C _4465_/A _4465_/B _4465_/C _4465_/D VPWR VGND sg13g2_nand4_1
X_4396_ _5261_/D _3815_/Y hold768/X _4409_/S VPWR VGND sg13g2_mux2_1
X_3416_ _3421_/B _3415_/A _3415_/B _3396_/Y VPWR VGND sg13g2_a21oi_1
X_3347_ _3347_/Y _5261_/Q _3685_/B _3346_/Y VPWR VGND sg13g2_a21oi_1
X_5017_ _5017_/Y _5145_/A VPWR VGND sg13g2_inv_1
X_3278_ _3278_/X _4433_/A _4433_/B _3278_/S VPWR VGND sg13g2_mux2_1
XFILLER_38_250 VPWR VGND sg13g2_fill_2
XFILLER_26_445 VPWR VGND sg13g2_decap_8
XFILLER_14_618 VPWR VGND sg13g2_decap_8
XFILLER_26_58 VPWR VGND sg13g2_decap_8
XFILLER_81_562 VPWR VGND sg13g2_decap_8
XFILLER_41_437 VPWR VGND sg13g2_fill_1
XFILLER_53_286 VPWR VGND sg13g2_fill_2
XFILLER_22_640 VPWR VGND sg13g2_decap_4
XFILLER_21_183 VPWR VGND sg13g2_decap_8
XFILLER_1_511 VPWR VGND sg13g2_decap_8
Xhold891 _4901_/A _5222_/Q VPWR VGND sg13g2_dlygate4sd3_1
Xhold880 _4694_/A _5201_/Q VPWR VGND sg13g2_dlygate4sd3_1
XFILLER_76_367 VPWR VGND sg13g2_fill_2
XFILLER_17_401 VPWR VGND sg13g2_fill_1
XFILLER_17_467 VPWR VGND sg13g2_decap_8
XFILLER_73_7 VPWR VGND sg13g2_decap_4
X_2580_ _2580_/Y _2580_/A VPWR VGND sg13g2_inv_1
XFILLER_4_371 VPWR VGND sg13g2_fill_1
X_4250_ _5380_/D _2544_/Y _4249_/B _4249_/Y VPWR VGND sg13g2_o21ai_1
X_4181_ _4192_/B _3721_/B _4154_/Y _4155_/Y VPWR VGND sg13g2_a21oi_1
X_3201_ _3202_/B _3201_/A _3201_/B _3228_/A VPWR VGND sg13g2_nor3_1
X_3132_ _4473_/B _4171_/B1 _3130_/Y _3131_/X _4203_/A _3127_/X VPWR VGND sg13g2_a221oi_1
XFILLER_79_172 VPWR VGND sg13g2_fill_2
XFILLER_67_312 VPWR VGND sg13g2_fill_2
X_3063_ _3063_/Y _4520_/A _3062_/Y _2684_/D VPWR VGND sg13g2_o21ai_1
XFILLER_35_231 VPWR VGND sg13g2_decap_8
XFILLER_23_404 VPWR VGND sg13g2_decap_4
XFILLER_50_223 VPWR VGND sg13g2_decap_8
XFILLER_63_595 VPWR VGND sg13g2_fill_2
XFILLER_50_234 VPWR VGND sg13g2_fill_1
X_3965_ _3966_/B _3938_/A _3936_/B _3896_/A VPWR VGND sg13g2_a21oi_1
XFILLER_10_109 VPWR VGND sg13g2_decap_8
X_3896_ _3901_/A _3896_/A _3896_/B VPWR VGND sg13g2_nand2_1
X_2916_ _2917_/C _2916_/A _2916_/B VPWR VGND sg13g2_nor2_1
XFILLER_12_16 VPWR VGND sg13g2_decap_8
X_2847_ _2850_/B _4644_/A _5438_/A _3403_/S VPWR VGND sg13g2_mux2_1
X_2778_ _3040_/A _3704_/A _4543_/B _2771_/Y VPWR VGND sg13g2_o21ai_1
X_4517_ _5177_/D hold806/X _4338_/A _4517_/S VPWR VGND sg13g2_mux2_1
X_4448_ _4451_/B _4448_/A _4448_/B _4448_/C _4448_/D VPWR VGND sg13g2_nor4_1
X_4379_ _5276_/D _4261_/A hold816/X _4393_/S VPWR VGND sg13g2_mux2_1
XFILLER_58_334 VPWR VGND sg13g2_decap_8
XFILLER_39_570 VPWR VGND sg13g2_fill_1
XFILLER_73_326 VPWR VGND sg13g2_decap_8
XFILLER_73_359 VPWR VGND sg13g2_decap_8
XFILLER_26_253 VPWR VGND sg13g2_decap_8
XFILLER_14_426 VPWR VGND sg13g2_decap_8
XFILLER_14_437 VPWR VGND sg13g2_fill_1
XFILLER_41_201 VPWR VGND sg13g2_decap_8
XFILLER_41_256 VPWR VGND sg13g2_decap_8
XFILLER_53_89 VPWR VGND sg13g2_fill_1
XFILLER_6_603 VPWR VGND sg13g2_decap_8
XFILLER_5_102 VPWR VGND sg13g2_decap_8
XFILLER_6_647 VPWR VGND sg13g2_decap_4
XFILLER_78_31 VPWR VGND sg13g2_fill_2
XFILLER_1_385 VPWR VGND sg13g2_fill_2
XFILLER_49_334 VPWR VGND sg13g2_decap_8
XFILLER_37_529 VPWR VGND sg13g2_fill_1
XFILLER_49_367 VPWR VGND sg13g2_fill_1
XFILLER_64_326 VPWR VGND sg13g2_decap_8
XFILLER_64_304 VPWR VGND sg13g2_decap_8
XFILLER_45_562 VPWR VGND sg13g2_fill_1
XFILLER_32_223 VPWR VGND sg13g2_decap_4
XFILLER_60_532 VPWR VGND sg13g2_decap_8
X_3750_ _3752_/D _3773_/A _3750_/B _4438_/A _3750_/D VPWR VGND sg13g2_nand4_1
XFILLER_13_481 VPWR VGND sg13g2_decap_8
X_2701_ _2708_/B _5307_/Q _2920_/A2 _3363_/A2 _5339_/Q VPWR VGND sg13g2_a22oi_1
XFILLER_9_452 VPWR VGND sg13g2_fill_1
X_3681_ _3829_/B _3834_/A _3681_/B VPWR VGND sg13g2_nand2b_1
X_5420_ _5420_/Q clkload5/A _5420_/D _5160_/Y VPWR VGND sg13g2_dfrbpq_1
X_2632_ _2632_/Y _5112_/A VPWR VGND sg13g2_inv_1
X_5351_ _5351_/Q clkload1/A _5351_/D _5091_/Y VPWR VGND sg13g2_dfrbpq_1
Xoutput204 io_wdata[16] _5452_/X VPWR VGND sg13g2_buf_1
Xoutput215 io_wdata[26] _5462_/X VPWR VGND sg13g2_buf_1
Xoutput226 io_wdata[7] _5443_/X VPWR VGND sg13g2_buf_1
X_2563_ _2818_/A _2563_/A VPWR VGND sg13g2_inv_1
X_5282_ _5282_/Q clkload6/A _5282_/D _5022_/Y VPWR VGND sg13g2_dfrbpq_1
X_4302_ _5341_/D _4338_/A hold766/X _4312_/S VPWR VGND sg13g2_mux2_1
XFILLER_4_50 VPWR VGND sg13g2_decap_4
X_4233_ _4233_/Y _4355_/A _4236_/S VPWR VGND sg13g2_nand2_1
X_4164_ _4168_/B _4212_/A1 _3726_/B _4163_/Y VPWR VGND sg13g2_o21ai_1
XFILLER_28_529 VPWR VGND sg13g2_decap_8
X_4095_ _4099_/B _4095_/A _4095_/B VPWR VGND sg13g2_nand2_1
X_3115_ _3130_/B _3115_/A _3129_/A VPWR VGND sg13g2_nor2_1
X_3046_ _3138_/B _3046_/A _3046_/B VPWR VGND sg13g2_nor2_1
XFILLER_67_186 VPWR VGND sg13g2_fill_2
XFILLER_55_348 VPWR VGND sg13g2_decap_8
XFILLER_70_318 VPWR VGND sg13g2_decap_8
XFILLER_36_584 VPWR VGND sg13g2_decap_8
XFILLER_70_329 VPWR VGND sg13g2_fill_1
XFILLER_23_289 VPWR VGND sg13g2_decap_8
XFILLER_51_598 VPWR VGND sg13g2_decap_8
X_4997_ _4997_/Y _5153_/A VPWR VGND sg13g2_inv_1
X_3948_ _3949_/B _3823_/A _3945_/Y _3947_/Y VPWR VGND sg13g2_o21ai_1
X_3879_ _3879_/Y _3879_/A _3879_/B _3879_/C VPWR VGND sg13g2_nor3_1
XFILLER_3_7 VPWR VGND sg13g2_decap_8
XFILLER_48_23 VPWR VGND sg13g2_fill_2
Xfanout420 _3392_/S _2656_/Y VPWR VGND sg13g2_buf_1
Xfanout431 _3211_/B _2999_/Y VPWR VGND sg13g2_buf_1
XFILLER_59_621 VPWR VGND sg13g2_fill_1
Xfanout442 _3688_/B1 _3556_/A2 VPWR VGND sg13g2_buf_1
Xfanout453 _2927_/A2 _2710_/X VPWR VGND sg13g2_buf_1
Xfanout464 _3683_/B1 _3546_/A2 VPWR VGND sg13g2_buf_1
Xfanout475 _3547_/B1 _2696_/X VPWR VGND sg13g2_buf_1
XFILLER_58_142 VPWR VGND sg13g2_decap_8
XFILLER_19_529 VPWR VGND sg13g2_decap_8
XFILLER_46_304 VPWR VGND sg13g2_decap_8
XFILLER_48_89 VPWR VGND sg13g2_decap_4
Xfanout486 _4094_/B1 _2670_/Y VPWR VGND sg13g2_buf_1
Xfanout497 _4441_/A _4074_/A1 VPWR VGND sg13g2_buf_1
XFILLER_73_112 VPWR VGND sg13g2_decap_8
XFILLER_27_551 VPWR VGND sg13g2_decap_8
XFILLER_46_359 VPWR VGND sg13g2_decap_8
XFILLER_64_55 VPWR VGND sg13g2_fill_2
XFILLER_64_44 VPWR VGND sg13g2_fill_2
XFILLER_80_54 VPWR VGND sg13g2_decap_8
XFILLER_10_484 VPWR VGND sg13g2_decap_8
XFILLER_6_444 VPWR VGND sg13g2_decap_8
XFILLER_36_7 VPWR VGND sg13g2_fill_1
XFILLER_77_440 VPWR VGND sg13g2_decap_4
XFILLER_37_304 VPWR VGND sg13g2_decap_8
XFILLER_77_495 VPWR VGND sg13g2_decap_8
XFILLER_18_540 VPWR VGND sg13g2_decap_8
XFILLER_18_562 VPWR VGND sg13g2_decap_8
XFILLER_33_521 VPWR VGND sg13g2_decap_8
X_4920_ _4920_/Y _5156_/A VPWR VGND sg13g2_inv_1
X_4851_ _4867_/A _4904_/A _4851_/B VPWR VGND sg13g2_xnor2_1
XFILLER_33_587 VPWR VGND sg13g2_decap_8
X_3802_ _3803_/B _4445_/C _3825_/B _4446_/A VPWR VGND sg13g2_a21o_1
XFILLER_60_351 VPWR VGND sg13g2_decap_8
XFILLER_20_226 VPWR VGND sg13g2_decap_8
X_4782_ _4782_/Y _4796_/A _4784_/B VPWR VGND sg13g2_nor2b_1
X_3733_ _3733_/Y _3733_/A _3733_/B VPWR VGND sg13g2_nand2_1
X_3664_ _3664_/Y _3658_/Y _3663_/Y _3868_/A VPWR VGND sg13g2_a21oi_1
X_5403_ _5403_/Q _5435_/CLK _5403_/D _5143_/Y VPWR VGND sg13g2_dfrbpq_1
X_2615_ _2615_/Y _2615_/A VPWR VGND sg13g2_inv_1
X_3595_ _4621_/B _3591_/Y _3593_/Y _3594_/Y VPWR VGND sg13g2_a21o_1
X_5334_ _5334_/Q _5430_/CLK _5334_/D _5074_/Y VPWR VGND sg13g2_dfrbpq_1
X_2546_ _2546_/Y _2546_/A VPWR VGND sg13g2_inv_1
X_5265_ _5265_/Q _5427_/CLK _5265_/D _5005_/Y VPWR VGND sg13g2_dfrbpq_1
X_5196_ _5196_/Q _5392_/CLK _5196_/D _4936_/Y VPWR VGND sg13g2_dfrbpq_1
X_4216_ _4216_/Y _2594_/Y _4217_/A1 _4218_/A2 VPWR VGND sg13g2_a21oi_1
X_4147_ _4147_/Y _4176_/A1 _4474_/C _4146_/Y VPWR VGND sg13g2_o21ai_1
XFILLER_68_473 VPWR VGND sg13g2_fill_2
XFILLER_55_101 VPWR VGND sg13g2_fill_2
X_4078_ _4078_/X _3714_/B _4077_/Y _3522_/X VPWR VGND sg13g2_a21o_1
X_3029_ _3268_/C _2869_/A _2869_/B _3028_/Y VPWR VGND sg13g2_a21oi_1
XFILLER_24_532 VPWR VGND sg13g2_decap_8
XFILLER_34_14 VPWR VGND sg13g2_decap_8
XFILLER_70_148 VPWR VGND sg13g2_fill_1
XFILLER_11_204 VPWR VGND sg13g2_decap_8
XFILLER_51_384 VPWR VGND sg13g2_decap_8
Xclkload2 clkload2/Y clkload2/A VPWR VGND sg13g2_inv_2
XFILLER_59_11 VPWR VGND sg13g2_fill_1
XFILLER_78_215 VPWR VGND sg13g2_fill_2
XFILLER_78_204 VPWR VGND sg13g2_fill_2
XFILLER_59_44 VPWR VGND sg13g2_decap_4
Xfanout250 _4311_/S _4284_/Y VPWR VGND sg13g2_buf_1
XFILLER_19_304 VPWR VGND sg13g2_fill_1
Xfanout261 _4236_/S _4237_/S VPWR VGND sg13g2_buf_1
Xfanout272 _3823_/A _2969_/X VPWR VGND sg13g2_buf_1
Xfanout283 _4162_/B _3366_/Y VPWR VGND sg13g2_buf_1
XFILLER_59_473 VPWR VGND sg13g2_decap_8
XFILLER_19_337 VPWR VGND sg13g2_decap_8
Xfanout294 _4745_/S _4739_/A1 VPWR VGND sg13g2_buf_1
XFILLER_74_432 VPWR VGND sg13g2_decap_8
XFILLER_59_484 VPWR VGND sg13g2_fill_2
XFILLER_46_167 VPWR VGND sg13g2_fill_1
XFILLER_15_510 VPWR VGND sg13g2_decap_4
XFILLER_74_487 VPWR VGND sg13g2_decap_8
XFILLER_61_126 VPWR VGND sg13g2_fill_1
XFILLER_15_576 VPWR VGND sg13g2_decap_8
XFILLER_15_587 VPWR VGND sg13g2_fill_1
XFILLER_30_524 VPWR VGND sg13g2_decap_8
Xhold709 hold709/X _5248_/Q VPWR VGND sg13g2_dlygate4sd3_1
X_3380_ _3385_/A _5246_/Q _3620_/B VPWR VGND sg13g2_nand2_1
XFILLER_2_480 VPWR VGND sg13g2_decap_4
X_5050_ _5050_/Y _5147_/A VPWR VGND sg13g2_inv_1
X_4001_ _4003_/B _3938_/A _4450_/A _4448_/B _4001_/B2 _4000_/Y VPWR VGND sg13g2_a221oi_1
XFILLER_65_421 VPWR VGND sg13g2_decap_8
XFILLER_37_156 VPWR VGND sg13g2_decap_8
XFILLER_37_167 VPWR VGND sg13g2_fill_1
XFILLER_65_498 VPWR VGND sg13g2_fill_1
X_4903_ _4903_/X _4904_/A _4904_/B VPWR VGND sg13g2_or2_1
XFILLER_33_351 VPWR VGND sg13g2_decap_4
X_4834_ _4834_/Y _4833_/A _4833_/B _4833_/C VPWR VGND sg13g2_a21oi_1
XFILLER_21_568 VPWR VGND sg13g2_decap_4
XFILLER_21_579 VPWR VGND sg13g2_fill_1
X_4765_ _4766_/A _4831_/A _4765_/B VPWR VGND sg13g2_xnor2_1
X_3716_ _3716_/Y _3506_/Y _3522_/X _4068_/B VPWR VGND sg13g2_a21oi_1
X_4696_ _4698_/B _4690_/A _4690_/B _4687_/Y VPWR VGND sg13g2_o21ai_1
X_3647_ _3648_/C _5385_/Q _3676_/A2 _3674_/B1 _5289_/Q VPWR VGND sg13g2_a22oi_1
X_3578_ _3578_/Y _3961_/A _3961_/B _3577_/Y VPWR VGND sg13g2_o21ai_1
X_5317_ _5317_/Q clkload5/A _5317_/D _5057_/Y VPWR VGND sg13g2_dfrbpq_1
XFILLER_29_47 VPWR VGND sg13g2_decap_8
XFILLER_29_613 VPWR VGND sg13g2_fill_1
X_5248_ _5248_/Q clkload8/A _5248_/D _4988_/Y VPWR VGND sg13g2_dfrbpq_1
XFILLER_28_112 VPWR VGND sg13g2_decap_8
XFILLER_29_624 VPWR VGND sg13g2_fill_2
XFILLER_29_635 VPWR VGND sg13g2_fill_1
X_5179_ _5179_/Q _5414_/CLK _5179_/D _4919_/Y VPWR VGND sg13g2_dfrbpq_1
XFILLER_75_229 VPWR VGND sg13g2_decap_8
XFILLER_56_421 VPWR VGND sg13g2_fill_2
XFILLER_44_605 VPWR VGND sg13g2_fill_1
XFILLER_56_443 VPWR VGND sg13g2_fill_2
XFILLER_16_307 VPWR VGND sg13g2_decap_8
XFILLER_28_178 VPWR VGND sg13g2_fill_2
XFILLER_43_159 VPWR VGND sg13g2_decap_8
XFILLER_24_351 VPWR VGND sg13g2_decap_8
XFILLER_71_479 VPWR VGND sg13g2_decap_8
XFILLER_24_373 VPWR VGND sg13g2_fill_1
XFILLER_24_395 VPWR VGND sg13g2_decap_8
XFILLER_3_200 VPWR VGND sg13g2_decap_8
XFILLER_3_211 VPWR VGND sg13g2_fill_1
XFILLER_3_255 VPWR VGND sg13g2_decap_8
XFILLER_79_513 VPWR VGND sg13g2_fill_2
XFILLER_66_207 VPWR VGND sg13g2_fill_1
XFILLER_66_229 VPWR VGND sg13g2_decap_8
XFILLER_19_80 VPWR VGND sg13g2_fill_2
XFILLER_74_240 VPWR VGND sg13g2_fill_1
XFILLER_59_292 VPWR VGND sg13g2_decap_8
XFILLER_34_115 VPWR VGND sg13g2_fill_2
XFILLER_74_251 VPWR VGND sg13g2_fill_1
XFILLER_74_295 VPWR VGND sg13g2_fill_1
XFILLER_15_351 VPWR VGND sg13g2_decap_4
XFILLER_15_373 VPWR VGND sg13g2_decap_8
X_2880_ _2880_/Y _2556_/Y _3386_/B _2880_/B1 VPWR VGND sg13g2_o21ai_1
XFILLER_30_398 VPWR VGND sg13g2_decap_8
XFILLER_11_590 VPWR VGND sg13g2_fill_1
X_4550_ _4550_/Y _4559_/B _5444_/A _4549_/Y VPWR VGND sg13g2_o21ai_1
X_4481_ _4481_/X _4481_/A _4481_/B _4481_/C _4481_/D VPWR VGND sg13g2_or4_1
X_3501_ _3502_/D _5378_/Q _3687_/B _3689_/A2 _5314_/Q VPWR VGND sg13g2_a22oi_1
XFILLER_7_594 VPWR VGND sg13g2_decap_8
X_3432_ _5458_/A _3432_/A _3432_/B _3432_/C _3432_/D VPWR VGND sg13g2_nand4_1
X_3363_ _3364_/C _5341_/Q _3363_/A2 _3363_/B1 _5277_/Q _3360_/Y VPWR VGND sg13g2_a221oi_1
X_5102_ _5102_/Y _5134_/A VPWR VGND sg13g2_inv_1
X_3294_ _3294_/Y _3921_/A _3295_/B VPWR VGND sg13g2_nand2_1
X_5033_ _5033_/Y _5161_/A VPWR VGND sg13g2_inv_1
XFILLER_26_605 VPWR VGND sg13g2_decap_8
XFILLER_38_443 VPWR VGND sg13g2_decap_8
XFILLER_53_413 VPWR VGND sg13g2_decap_4
XFILLER_15_38 VPWR VGND sg13g2_fill_2
XFILLER_15_49 VPWR VGND sg13g2_decap_4
XFILLER_61_490 VPWR VGND sg13g2_decap_8
X_4817_ _4828_/B _4817_/A _4817_/B _4827_/D VPWR VGND sg13g2_nand3_1
XFILLER_21_365 VPWR VGND sg13g2_decap_8
Xrebuffer603 _3996_/A _3763_/C VPWR VGND sg13g2_buf_1
X_4748_ _4751_/B _4761_/B _4748_/B VPWR VGND sg13g2_nand2_1
X_4679_ _4681_/A _4679_/A _4679_/B VPWR VGND sg13g2_nand2_1
XFILLER_0_236 VPWR VGND sg13g2_fill_1
XFILLER_0_247 VPWR VGND sg13g2_fill_1
XFILLER_48_207 VPWR VGND sg13g2_decap_8
XFILLER_76_516 VPWR VGND sg13g2_decap_8
XFILLER_29_421 VPWR VGND sg13g2_decap_4
XFILLER_56_34 VPWR VGND sg13g2_decap_8
XFILLER_29_465 VPWR VGND sg13g2_decap_8
XFILLER_44_413 VPWR VGND sg13g2_decap_8
XFILLER_56_251 VPWR VGND sg13g2_decap_4
XFILLER_32_619 VPWR VGND sg13g2_decap_8
XFILLER_72_11 VPWR VGND sg13g2_fill_2
XFILLER_12_310 VPWR VGND sg13g2_decap_8
XFILLER_52_490 VPWR VGND sg13g2_decap_8
XFILLER_71_298 VPWR VGND sg13g2_decap_8
XFILLER_12_376 VPWR VGND sg13g2_decap_4
XFILLER_12_398 VPWR VGND sg13g2_decap_4
XFILLER_4_520 VPWR VGND sg13g2_decap_8
XFILLER_4_531 VPWR VGND sg13g2_fill_2
XFILLER_67_516 VPWR VGND sg13g2_decap_8
XFILLER_75_571 VPWR VGND sg13g2_decap_8
XFILLER_75_560 VPWR VGND sg13g2_fill_2
XFILLER_35_435 VPWR VGND sg13g2_fill_2
XFILLER_23_619 VPWR VGND sg13g2_fill_2
X_3981_ _3983_/C _3999_/B _3993_/B VPWR VGND sg13g2_nand2b_1
XFILLER_50_427 VPWR VGND sg13g2_decap_8
X_2932_ _2951_/A _4439_/C _3022_/B VPWR VGND sg13g2_and2_1
XFILLER_43_490 VPWR VGND sg13g2_decap_8
X_2863_ _2863_/Y _5232_/Q _3401_/A2 _3398_/B1 VPWR VGND sg13g2_a21oi_1
X_4602_ _4602_/Y _5456_/A _4602_/B VPWR VGND sg13g2_xnor2_1
X_2794_ _5443_/A _2790_/Y _2792_/Y _2793_/Y VPWR VGND sg13g2_a21oi_2
X_4533_ _4533_/Y _4559_/B _5439_/A _4528_/Y VPWR VGND sg13g2_o21ai_1
XFILLER_7_83 VPWR VGND sg13g2_fill_2
X_4464_ _4465_/D _3313_/A _4464_/A2 _2959_/B VPWR VGND sg13g2_a21oi_1
X_4395_ _5262_/D _3796_/Y hold796/X _4409_/S VPWR VGND sg13g2_mux2_1
X_3415_ _3415_/Y _3415_/A _3415_/B VPWR VGND sg13g2_nand2_1
X_3346_ _3346_/Y _3346_/A _3346_/B _3346_/C VPWR VGND sg13g2_nand3_1
X_5016_ _5016_/Y _5112_/A VPWR VGND sg13g2_inv_1
X_3277_ _3281_/B _2974_/B _4211_/A2 _3233_/B _3275_/A VPWR VGND sg13g2_a22oi_1
XFILLER_26_424 VPWR VGND sg13g2_decap_8
XFILLER_26_479 VPWR VGND sg13g2_fill_2
XFILLER_13_129 VPWR VGND sg13g2_decap_8
XFILLER_41_449 VPWR VGND sg13g2_decap_8
Xhold881 _2624_/A _5203_/Q VPWR VGND sg13g2_dlygate4sd3_1
Xhold870 _5196_/D _4655_/Y VPWR VGND sg13g2_dlygate4sd3_1
XFILLER_49_505 VPWR VGND sg13g2_fill_2
Xhold892 _4817_/A _5213_/Q VPWR VGND sg13g2_dlygate4sd3_1
XFILLER_67_11 VPWR VGND sg13g2_fill_1
XFILLER_67_44 VPWR VGND sg13g2_fill_2
XFILLER_64_508 VPWR VGND sg13g2_decap_8
XFILLER_32_416 VPWR VGND sg13g2_fill_2
XFILLER_72_596 VPWR VGND sg13g2_decap_8
XFILLER_9_601 VPWR VGND sg13g2_fill_1
XFILLER_40_460 VPWR VGND sg13g2_fill_1
XFILLER_9_645 VPWR VGND sg13g2_decap_8
XFILLER_8_166 VPWR VGND sg13g2_decap_4
XFILLER_66_7 VPWR VGND sg13g2_decap_4
X_4180_ _4192_/A _4152_/A _4152_/B _4172_/B VPWR VGND sg13g2_a21oi_1
X_3200_ _3200_/Y _3201_/B _3228_/A _3201_/A VPWR VGND sg13g2_o21ai_1
X_3131_ _3131_/X _3131_/A _3131_/B VPWR VGND sg13g2_xor2_1
XFILLER_67_324 VPWR VGND sg13g2_decap_8
XFILLER_67_357 VPWR VGND sg13g2_decap_4
XFILLER_55_508 VPWR VGND sg13g2_decap_4
X_3062_ _3062_/Y _4490_/A _2682_/B _2671_/B _3000_/C VPWR VGND sg13g2_a22oi_1
XFILLER_63_574 VPWR VGND sg13g2_decap_8
XFILLER_35_298 VPWR VGND sg13g2_decap_8
XFILLER_23_449 VPWR VGND sg13g2_decap_8
Xclkbuf_leaf_15_clk _5216_/CLK clkbuf_2_3__f_clk/X VPWR VGND sg13g2_buf_8
X_3964_ _3978_/A _4461_/A _3971_/B VPWR VGND sg13g2_nor2_1
X_3895_ _3895_/Y _3895_/A _3895_/B VPWR VGND sg13g2_xnor2_1
X_2915_ _2917_/B _3184_/B _3161_/A _2915_/C _2915_/D VPWR VGND sg13g2_nor4_1
X_2846_ _4530_/B _2844_/Y _2842_/Y _2845_/Y VPWR VGND sg13g2_a21oi_2
X_2777_ _5442_/A _4543_/B VPWR VGND sg13g2_inv_1
X_4516_ _5178_/D hold654/X _4178_/Y _4516_/S VPWR VGND sg13g2_mux2_1
X_4447_ _4450_/D _4447_/A1 _4462_/A _3765_/A VPWR VGND sg13g2_o21ai_1
X_4378_ _5277_/D _4338_/A hold815/X _4388_/S VPWR VGND sg13g2_mux2_1
XFILLER_58_313 VPWR VGND sg13g2_decap_8
X_3329_ _3332_/B _5326_/Q _3674_/A2 _3689_/B1 _5422_/Q VPWR VGND sg13g2_a22oi_1
XFILLER_46_519 VPWR VGND sg13g2_decap_8
XFILLER_73_316 VPWR VGND sg13g2_fill_1
XFILLER_58_379 VPWR VGND sg13g2_decap_8
XFILLER_14_405 VPWR VGND sg13g2_decap_8
XFILLER_26_243 VPWR VGND sg13g2_fill_1
XFILLER_54_563 VPWR VGND sg13g2_decap_8
XFILLER_81_371 VPWR VGND sg13g2_fill_2
XFILLER_53_24 VPWR VGND sg13g2_decap_4
XFILLER_14_449 VPWR VGND sg13g2_decap_4
XFILLER_53_68 VPWR VGND sg13g2_decap_8
XFILLER_78_98 VPWR VGND sg13g2_fill_1
XFILLER_76_143 VPWR VGND sg13g2_decap_4
XFILLER_32_202 VPWR VGND sg13g2_decap_8
XFILLER_60_511 VPWR VGND sg13g2_decap_8
XFILLER_60_588 VPWR VGND sg13g2_decap_8
X_2700_ _2700_/Y _2895_/C _2696_/B VPWR VGND sg13g2_nor2b_1
XFILLER_9_431 VPWR VGND sg13g2_decap_8
X_3680_ _3681_/B _3679_/A _5465_/A _3847_/B VPWR VGND sg13g2_o21ai_1
X_2631_ _4884_/A _2631_/A VPWR VGND sg13g2_inv_1
X_5350_ _5350_/Q clkload6/A _5350_/D _5090_/Y VPWR VGND sg13g2_dfrbpq_1
Xoutput205 io_wdata[17] _5453_/X VPWR VGND sg13g2_buf_1
Xoutput216 io_wdata[27] _5463_/X VPWR VGND sg13g2_buf_1
X_2562_ _2901_/A _2562_/A VPWR VGND sg13g2_inv_1
X_5281_ _5281_/Q clkload7/A _5281_/D _5021_/Y VPWR VGND sg13g2_dfrbpq_1
Xoutput227 io_wdata[8] _5444_/X VPWR VGND sg13g2_buf_1
X_4301_ _5342_/D _4178_/Y hold724/X _4311_/S VPWR VGND sg13g2_mux2_1
X_4232_ _5395_/D _2894_/A _4236_/S _4231_/Y VPWR VGND sg13g2_o21ai_1
Xclkbuf_leaf_4_clk _5424_/CLK clkbuf_leaf_9_clk/A VPWR VGND sg13g2_buf_8
X_4163_ _4163_/Y _4209_/A1 _4158_/A _4449_/B _4209_/B1 VPWR VGND sg13g2_a22oi_1
XFILLER_68_644 VPWR VGND sg13g2_decap_8
X_4094_ _4099_/A _4095_/B _3566_/B _4094_/B1 VPWR VGND sg13g2_o21ai_1
X_3114_ _5433_/D hold699/X _4224_/A _4514_/S VPWR VGND sg13g2_mux2_1
XFILLER_67_165 VPWR VGND sg13g2_decap_8
X_3045_ _3046_/B _3253_/A _3026_/B _3269_/A _3033_/Y _3044_/Y VPWR VGND sg13g2_a221oi_1
XFILLER_48_390 VPWR VGND sg13g2_fill_2
X_4996_ _4996_/Y _5156_/A VPWR VGND sg13g2_inv_1
XFILLER_23_16 VPWR VGND sg13g2_decap_8
XFILLER_23_268 VPWR VGND sg13g2_decap_8
X_3947_ _3947_/Y _3580_/Y _3736_/B _3946_/Y VPWR VGND sg13g2_o21ai_1
X_3878_ _3885_/B _3878_/A _3878_/B _3878_/C VPWR VGND sg13g2_nor3_1
X_2829_ _2829_/Y _5266_/Q _3400_/A2 _3400_/B1 _5330_/Q _2828_/Y VPWR VGND sg13g2_a221oi_1
XFILLER_3_618 VPWR VGND sg13g2_fill_2
Xfanout410 _3887_/B _2679_/X VPWR VGND sg13g2_buf_1
Xfanout421 _4461_/A _3239_/A VPWR VGND sg13g2_buf_1
Xfanout432 _3676_/B1 _3464_/B VPWR VGND sg13g2_buf_1
Xfanout443 _3371_/A2 _3400_/A2 VPWR VGND sg13g2_buf_2
Xfanout454 _3668_/B1 _3684_/B1 VPWR VGND sg13g2_buf_1
Xfanout465 _3363_/A2 _3004_/A2 VPWR VGND sg13g2_buf_1
XFILLER_58_121 VPWR VGND sg13g2_decap_4
XFILLER_48_79 VPWR VGND sg13g2_fill_2
Xfanout476 _3685_/B _3620_/B VPWR VGND sg13g2_buf_1
Xfanout487 _3879_/A _2669_/Y VPWR VGND sg13g2_buf_1
Xfanout498 _4074_/A1 _2645_/Y VPWR VGND sg13g2_buf_1
XFILLER_46_338 VPWR VGND sg13g2_fill_2
XFILLER_74_647 VPWR VGND sg13g2_decap_4
XFILLER_73_168 VPWR VGND sg13g2_decap_8
XFILLER_42_522 VPWR VGND sg13g2_fill_1
XFILLER_81_190 VPWR VGND sg13g2_fill_1
XFILLER_54_393 VPWR VGND sg13g2_decap_8
XFILLER_42_588 VPWR VGND sg13g2_decap_8
XFILLER_80_33 VPWR VGND sg13g2_decap_8
XFILLER_80_11 VPWR VGND sg13g2_decap_8
XFILLER_6_401 VPWR VGND sg13g2_fill_1
XFILLER_10_463 VPWR VGND sg13g2_decap_8
XFILLER_6_412 VPWR VGND sg13g2_decap_8
XFILLER_6_478 VPWR VGND sg13g2_decap_4
XFILLER_2_651 VPWR VGND sg13g2_fill_1
XFILLER_69_408 VPWR VGND sg13g2_decap_8
XFILLER_1_150 VPWR VGND sg13g2_decap_8
XFILLER_69_419 VPWR VGND sg13g2_fill_1
XFILLER_29_7 VPWR VGND sg13g2_fill_2
XFILLER_49_110 VPWR VGND sg13g2_decap_8
XFILLER_64_135 VPWR VGND sg13g2_decap_4
XFILLER_33_500 VPWR VGND sg13g2_fill_2
X_4850_ _4869_/A _4904_/A _4851_/B VPWR VGND sg13g2_or2_1
X_3801_ _3812_/B _3358_/Y _3744_/Y _3800_/Y VPWR VGND sg13g2_o21ai_1
X_4781_ _4784_/B _4788_/B _4781_/B VPWR VGND sg13g2_nand2_1
XFILLER_60_396 VPWR VGND sg13g2_decap_8
XFILLER_20_249 VPWR VGND sg13g2_decap_8
X_3732_ _4040_/C _4132_/B _4132_/C _3733_/B VPWR VGND sg13g2_o21ai_1
X_3663_ _3663_/Y _3893_/B _3893_/C VPWR VGND sg13g2_nand2_1
X_5402_ _5402_/Q _5434_/CLK _5402_/D _5142_/Y VPWR VGND sg13g2_dfrbpq_1
X_2614_ _2614_/Y _2614_/A VPWR VGND sg13g2_inv_1
X_5333_ _5333_/Q _5435_/CLK _5333_/D _5073_/Y VPWR VGND sg13g2_dfrbpq_1
X_3594_ _3594_/Y _5256_/Q _4603_/A1 _2754_/B VPWR VGND sg13g2_a21oi_1
X_2545_ _2545_/Y _2545_/A VPWR VGND sg13g2_inv_1
X_5264_ _5264_/Q _5427_/CLK _5264_/D _5004_/Y VPWR VGND sg13g2_dfrbpq_1
X_5195_ _5195_/Q _5432_/CLK _5195_/D _4935_/Y VPWR VGND sg13g2_dfrbpq_1
X_4215_ _4476_/C _4215_/A _4215_/B _4215_/C _4215_/D VPWR VGND sg13g2_nand4_1
XFILLER_28_305 VPWR VGND sg13g2_fill_1
X_4146_ _4146_/Y _2599_/Y _4146_/A2 _4218_/A2 VPWR VGND sg13g2_a21oi_1
XFILLER_68_452 VPWR VGND sg13g2_decap_8
XFILLER_55_113 VPWR VGND sg13g2_decap_4
X_4077_ _4077_/Y _3715_/X _4133_/B _3541_/Y VPWR VGND sg13g2_a21oi_1
XFILLER_36_360 VPWR VGND sg13g2_decap_4
XFILLER_43_319 VPWR VGND sg13g2_fill_1
X_3028_ _3028_/Y _2769_/Y _2875_/Y _2884_/A _3403_/S _2886_/Y VPWR VGND sg13g2_a221oi_1
XFILLER_36_382 VPWR VGND sg13g2_decap_8
XFILLER_70_127 VPWR VGND sg13g2_decap_8
XFILLER_24_588 VPWR VGND sg13g2_fill_2
X_4979_ _4979_/Y _5174_/A VPWR VGND sg13g2_inv_1
XFILLER_11_249 VPWR VGND sg13g2_fill_1
Xclkload3 clkload3/Y clkload3/A VPWR VGND sg13g2_inv_2
XFILLER_7_209 VPWR VGND sg13g2_fill_1
XFILLER_50_36 VPWR VGND sg13g2_decap_8
XFILLER_3_415 VPWR VGND sg13g2_decap_8
XFILLER_3_426 VPWR VGND sg13g2_fill_1
XFILLER_3_459 VPWR VGND sg13g2_decap_8
XFILLER_59_23 VPWR VGND sg13g2_decap_4
Xfanout240 _4335_/B _4357_/S VPWR VGND sg13g2_buf_1
XFILLER_78_249 VPWR VGND sg13g2_fill_1
Xfanout251 _4249_/B _4258_/S VPWR VGND sg13g2_buf_1
Xfanout262 _4237_/S _4235_/S VPWR VGND sg13g2_buf_1
Xfanout273 _4111_/A _2969_/X VPWR VGND sg13g2_buf_1
XFILLER_75_11 VPWR VGND sg13g2_fill_2
XFILLER_47_625 VPWR VGND sg13g2_decap_4
Xfanout284 _4116_/A _3010_/X VPWR VGND sg13g2_buf_1
Xfanout295 _4814_/A _4739_/A1 VPWR VGND sg13g2_buf_1
XFILLER_74_400 VPWR VGND sg13g2_decap_8
XFILLER_46_146 VPWR VGND sg13g2_fill_2
XFILLER_74_455 VPWR VGND sg13g2_fill_1
XFILLER_34_319 VPWR VGND sg13g2_decap_8
XFILLER_74_499 VPWR VGND sg13g2_fill_2
XFILLER_27_393 VPWR VGND sg13g2_fill_2
XFILLER_15_555 VPWR VGND sg13g2_fill_2
XFILLER_30_503 VPWR VGND sg13g2_decap_8
XFILLER_15_599 VPWR VGND sg13g2_decap_8
XFILLER_42_396 VPWR VGND sg13g2_fill_1
XFILLER_10_271 VPWR VGND sg13g2_decap_8
XFILLER_10_282 VPWR VGND sg13g2_fill_1
XFILLER_40_80 VPWR VGND sg13g2_fill_1
XFILLER_6_297 VPWR VGND sg13g2_decap_4
XFILLER_69_227 VPWR VGND sg13g2_decap_8
XFILLER_27_4 VPWR VGND sg13g2_fill_1
X_4000_ _4000_/Y _3879_/A _3983_/A _3998_/Y VPWR VGND sg13g2_o21ai_1
XFILLER_1_30 VPWR VGND sg13g2_decap_8
XFILLER_77_271 VPWR VGND sg13g2_decap_8
XFILLER_65_400 VPWR VGND sg13g2_decap_8
XFILLER_1_63 VPWR VGND sg13g2_decap_4
XFILLER_37_135 VPWR VGND sg13g2_decap_8
XFILLER_53_606 VPWR VGND sg13g2_decap_8
XFILLER_25_308 VPWR VGND sg13g2_decap_8
XFILLER_65_477 VPWR VGND sg13g2_decap_8
X_4902_ _4904_/B hold846/X _4911_/B VPWR VGND sg13g2_nand2b_1
XFILLER_21_525 VPWR VGND sg13g2_decap_4
XFILLER_33_396 VPWR VGND sg13g2_decap_8
X_4833_ _4833_/X _4833_/A _4833_/B _4833_/C VPWR VGND sg13g2_and3_1
X_4764_ _4764_/Y _4764_/A VPWR VGND sg13g2_inv_1
X_3715_ _3715_/X _3715_/A _4110_/B VPWR VGND sg13g2_and2_1
X_4695_ _4695_/Y _4697_/B VPWR VGND sg13g2_inv_1
X_3646_ _3648_/B _5417_/Q _3689_/B1 _2714_/B VPWR VGND sg13g2_a21oi_1
X_3577_ _3577_/Y _3453_/B _3936_/B VPWR VGND sg13g2_nand2b_1
X_5316_ _5316_/Q clkload6/A _5316_/D _5056_/Y VPWR VGND sg13g2_dfrbpq_1
XFILLER_0_429 VPWR VGND sg13g2_fill_2
X_5247_ _5247_/Q _5424_/CLK _5247_/D _4987_/Y VPWR VGND sg13g2_dfrbpq_1
X_5178_ _5178_/Q _5424_/CLK _5178_/D _4918_/Y VPWR VGND sg13g2_dfrbpq_1
XFILLER_56_400 VPWR VGND sg13g2_decap_4
X_4129_ _5408_/D hold662/X _4255_/A _4224_/B VPWR VGND sg13g2_mux2_1
XFILLER_44_628 VPWR VGND sg13g2_decap_4
XFILLER_45_14 VPWR VGND sg13g2_decap_8
XFILLER_56_477 VPWR VGND sg13g2_fill_1
XFILLER_24_330 VPWR VGND sg13g2_decap_8
XFILLER_71_458 VPWR VGND sg13g2_decap_8
XFILLER_12_569 VPWR VGND sg13g2_decap_8
XFILLER_61_46 VPWR VGND sg13g2_fill_2
XFILLER_61_35 VPWR VGND sg13g2_decap_8
XFILLER_20_591 VPWR VGND sg13g2_decap_8
XFILLER_3_267 VPWR VGND sg13g2_fill_1
XFILLER_47_400 VPWR VGND sg13g2_fill_2
XFILLER_59_282 VPWR VGND sg13g2_fill_1
XFILLER_19_146 VPWR VGND sg13g2_fill_2
XFILLER_19_168 VPWR VGND sg13g2_fill_2
XFILLER_35_617 VPWR VGND sg13g2_decap_8
XFILLER_47_477 VPWR VGND sg13g2_fill_1
XFILLER_62_414 VPWR VGND sg13g2_fill_2
XFILLER_34_149 VPWR VGND sg13g2_fill_2
XFILLER_62_425 VPWR VGND sg13g2_fill_1
XFILLER_15_330 VPWR VGND sg13g2_decap_8
XFILLER_50_609 VPWR VGND sg13g2_fill_1
XFILLER_30_333 VPWR VGND sg13g2_decap_8
XFILLER_30_344 VPWR VGND sg13g2_fill_1
XFILLER_42_193 VPWR VGND sg13g2_fill_1
XFILLER_30_377 VPWR VGND sg13g2_decap_8
X_3500_ _3502_/C _5282_/Q _3688_/B1 _3464_/B _5346_/Q VPWR VGND sg13g2_a22oi_1
XFILLER_7_551 VPWR VGND sg13g2_decap_8
X_4480_ _4480_/Y _4480_/A _4480_/B _4480_/C VPWR VGND sg13g2_nand3_1
X_3431_ _3432_/D _5185_/Q _3644_/B _3674_/B1 _5285_/Q VPWR VGND sg13g2_a22oi_1
X_3362_ _3364_/B _5177_/Q _2800_/B _3548_/A2 _5309_/Q VPWR VGND sg13g2_a22oi_1
XFILLER_32_2 VPWR VGND sg13g2_fill_1
X_5101_ _5101_/Y _5167_/A VPWR VGND sg13g2_inv_1
X_3293_ _3295_/B _4440_/B _3313_/A VPWR VGND sg13g2_xnor2_1
XFILLER_38_422 VPWR VGND sg13g2_decap_8
X_5032_ _5032_/Y _5125_/A VPWR VGND sg13g2_inv_1
XFILLER_78_580 VPWR VGND sg13g2_decap_4
XFILLER_18_0 VPWR VGND sg13g2_decap_8
XFILLER_38_477 VPWR VGND sg13g2_fill_2
XFILLER_18_190 VPWR VGND sg13g2_fill_1
X_4816_ _4816_/Y _5213_/Q _4827_/D _4817_/B VPWR VGND sg13g2_a21oi_1
Xrebuffer604 _3140_/B _2994_/D VPWR VGND sg13g2_buf_1
X_4747_ _4749_/C _4740_/A _4740_/B _2627_/Y VPWR VGND sg13g2_o21ai_1
X_4678_ _4679_/B _4676_/A _4678_/B VPWR VGND sg13g2_nand2b_1
X_3629_ _3631_/C _5386_/Q _3687_/B _2714_/B VPWR VGND sg13g2_a21oi_1
XFILLER_0_215 VPWR VGND sg13g2_decap_8
XFILLER_29_400 VPWR VGND sg13g2_decap_8
XFILLER_76_539 VPWR VGND sg13g2_decap_8
XFILLER_29_444 VPWR VGND sg13g2_decap_8
XFILLER_56_230 VPWR VGND sg13g2_decap_8
XFILLER_16_105 VPWR VGND sg13g2_decap_4
XFILLER_44_403 VPWR VGND sg13g2_fill_2
XFILLER_71_222 VPWR VGND sg13g2_decap_8
XFILLER_72_23 VPWR VGND sg13g2_decap_4
XFILLER_8_337 VPWR VGND sg13g2_fill_1
XFILLER_8_359 VPWR VGND sg13g2_decap_8
XFILLER_4_543 VPWR VGND sg13g2_decap_8
XFILLER_21_93 VPWR VGND sg13g2_decap_4
XFILLER_11_7 VPWR VGND sg13g2_fill_1
XFILLER_35_458 VPWR VGND sg13g2_decap_8
XFILLER_50_406 VPWR VGND sg13g2_decap_8
X_3980_ _3993_/B _4030_/A _4041_/B _3709_/Y VPWR VGND sg13g2_o21ai_1
XFILLER_15_160 VPWR VGND sg13g2_decap_8
X_2931_ _3022_/B _4706_/A _5445_/A _3392_/S VPWR VGND sg13g2_mux2_1
Xclkbuf_0_clk clkbuf_0_clk/X clk VPWR VGND sg13g2_buf_16
X_4601_ _4608_/C _5456_/A _4602_/B VPWR VGND sg13g2_nand2b_1
X_2862_ _2862_/Y _5264_/Q _3400_/A2 _3400_/B1 _5328_/Q _2861_/Y VPWR VGND sg13g2_a221oi_1
X_2793_ _2793_/Y _5238_/Q _2714_/A _2880_/B1 VPWR VGND sg13g2_a21oi_1
X_4532_ _4532_/Y _4652_/A _4543_/A VPWR VGND sg13g2_nor2_1
X_4463_ _4466_/B _4463_/A _4463_/B VPWR VGND sg13g2_nor2_1
XFILLER_7_95 VPWR VGND sg13g2_fill_2
X_3414_ _3415_/B _4198_/B _4208_/B VPWR VGND sg13g2_nand2b_1
X_4394_ _4410_/S _4394_/A _4394_/B _4394_/C VPWR VGND sg13g2_nand3_1
X_3345_ _3346_/C _5193_/Q _3637_/B _3682_/B1 _5421_/Q VPWR VGND sg13g2_a22oi_1
X_3276_ _3281_/A _2986_/A _2850_/B _4188_/B2 VPWR VGND sg13g2_o21ai_1
X_5015_ _5015_/Y _5168_/A VPWR VGND sg13g2_inv_1
XFILLER_38_241 VPWR VGND sg13g2_fill_2
XFILLER_38_263 VPWR VGND sg13g2_fill_1
XFILLER_38_285 VPWR VGND sg13g2_decap_8
XFILLER_66_594 VPWR VGND sg13g2_fill_2
XFILLER_41_428 VPWR VGND sg13g2_decap_8
XFILLER_81_597 VPWR VGND sg13g2_decap_8
XFILLER_21_152 VPWR VGND sg13g2_decap_4
XFILLER_5_318 VPWR VGND sg13g2_decap_8
Xhold882 _4805_/A _5213_/Q VPWR VGND sg13g2_dlygate4sd3_1
Xhold871 _4734_/A _5205_/Q VPWR VGND sg13g2_dlygate4sd3_1
Xhold860 _4858_/A _5218_/Q VPWR VGND sg13g2_dlygate4sd3_1
XFILLER_1_546 VPWR VGND sg13g2_decap_8
Xhold893 _2625_/A _5204_/Q VPWR VGND sg13g2_dlygate4sd3_1
XFILLER_67_23 VPWR VGND sg13g2_decap_8
XFILLER_76_325 VPWR VGND sg13g2_decap_8
XFILLER_67_89 VPWR VGND sg13g2_decap_8
XFILLER_76_369 VPWR VGND sg13g2_fill_1
XFILLER_17_414 VPWR VGND sg13g2_decap_8
XFILLER_29_274 VPWR VGND sg13g2_decap_4
XFILLER_72_542 VPWR VGND sg13g2_decap_8
XFILLER_32_428 VPWR VGND sg13g2_decap_8
XFILLER_40_483 VPWR VGND sg13g2_decap_8
XFILLER_8_134 VPWR VGND sg13g2_decap_8
XFILLER_32_70 VPWR VGND sg13g2_fill_1
XFILLER_32_81 VPWR VGND sg13g2_fill_2
XFILLER_4_395 VPWR VGND sg13g2_fill_2
X_3130_ _3130_/Y _3131_/A _3130_/B VPWR VGND sg13g2_xnor2_1
XFILLER_67_347 VPWR VGND sg13g2_fill_1
XFILLER_48_572 VPWR VGND sg13g2_fill_2
X_3061_ _4476_/A _3061_/A VPWR VGND sg13g2_inv_1
XFILLER_35_277 VPWR VGND sg13g2_decap_8
XFILLER_63_597 VPWR VGND sg13g2_fill_1
X_3963_ _3971_/B _4448_/B _3996_/A VPWR VGND sg13g2_xnor2_1
X_3894_ _3905_/B _3894_/A _3894_/B VPWR VGND sg13g2_nor2_1
X_2914_ _2914_/Y _2915_/C _2915_/D VPWR VGND sg13g2_nor2_1
X_2845_ _2845_/Y _5233_/Q _2714_/A _3398_/B1 VPWR VGND sg13g2_a21oi_1
X_4515_ _5179_/D hold731/X _4335_/A _4516_/S VPWR VGND sg13g2_mux2_1
X_2776_ _4543_/B _2776_/A _2776_/B _2776_/C _2776_/D VPWR VGND sg13g2_and4_1
X_4446_ _4452_/D _4446_/A _4446_/B _4446_/C VPWR VGND sg13g2_nor3_1
X_4377_ _5278_/D _4178_/Y hold713/X _4387_/S VPWR VGND sg13g2_mux2_1
X_3328_ _3332_/A _5194_/Q _3644_/B VPWR VGND sg13g2_nand2_1
XFILLER_58_358 VPWR VGND sg13g2_decap_8
XFILLER_39_550 VPWR VGND sg13g2_fill_1
X_3259_ _3261_/C _2824_/X _3232_/C _3231_/B VPWR VGND sg13g2_a21oi_1
XFILLER_54_520 VPWR VGND sg13g2_fill_2
XFILLER_54_542 VPWR VGND sg13g2_decap_8
XFILLER_54_597 VPWR VGND sg13g2_decap_8
XFILLER_41_236 VPWR VGND sg13g2_decap_8
XFILLER_22_461 VPWR VGND sg13g2_decap_8
XFILLER_22_494 VPWR VGND sg13g2_decap_4
XFILLER_5_137 VPWR VGND sg13g2_fill_2
XFILLER_78_33 VPWR VGND sg13g2_fill_1
XFILLER_1_332 VPWR VGND sg13g2_fill_2
Xhold690 hold690/X _5334_/Q VPWR VGND sg13g2_dlygate4sd3_1
XFILLER_78_66 VPWR VGND sg13g2_fill_2
XFILLER_1_376 VPWR VGND sg13g2_fill_2
XFILLER_76_122 VPWR VGND sg13g2_decap_8
XFILLER_76_199 VPWR VGND sg13g2_fill_1
XFILLER_17_222 VPWR VGND sg13g2_decap_8
XFILLER_45_542 VPWR VGND sg13g2_decap_4
XFILLER_45_597 VPWR VGND sg13g2_decap_8
XFILLER_72_350 VPWR VGND sg13g2_decap_8
XFILLER_72_394 VPWR VGND sg13g2_decap_8
XFILLER_60_567 VPWR VGND sg13g2_decap_8
X_2630_ _4857_/A _4858_/A VPWR VGND sg13g2_inv_1
XFILLER_9_476 VPWR VGND sg13g2_decap_8
Xoutput206 io_wdata[18] _5454_/X VPWR VGND sg13g2_buf_1
Xoutput217 io_wdata[28] _5464_/X VPWR VGND sg13g2_buf_1
X_2561_ _2561_/Y _2561_/A VPWR VGND sg13g2_inv_1
XFILLER_57_4 VPWR VGND sg13g2_fill_2
X_5280_ _5280_/Q _5414_/CLK _5280_/D _5020_/Y VPWR VGND sg13g2_dfrbpq_1
Xoutput228 io_wdata[9] _5445_/X VPWR VGND sg13g2_buf_1
X_4300_ _5343_/D _4335_/A hold759/X _4311_/S VPWR VGND sg13g2_mux2_1
X_4231_ _4231_/Y _4353_/A _4236_/S VPWR VGND sg13g2_nand2_1
XFILLER_4_85 VPWR VGND sg13g2_fill_1
XFILLER_68_601 VPWR VGND sg13g2_decap_8
X_4162_ _4162_/Y _4162_/A _4162_/B VPWR VGND sg13g2_nor2_1
X_4093_ _4100_/B _4095_/B _4093_/B VPWR VGND sg13g2_xnor2_1
X_3113_ _4224_/A _2591_/Y _3246_/A2 _3111_/Y _3112_/Y VPWR VGND sg13g2_a22oi_1
XFILLER_67_144 VPWR VGND sg13g2_decap_8
X_3044_ _3044_/Y _3184_/B _3161_/A _3201_/A _3044_/D VPWR VGND sg13g2_nand4_1
XFILLER_51_512 VPWR VGND sg13g2_decap_4
XFILLER_63_350 VPWR VGND sg13g2_decap_8
X_4995_ _4995_/Y _5001_/A VPWR VGND sg13g2_inv_1
X_3946_ _3946_/Y _3580_/Y _3736_/B _3856_/A VPWR VGND sg13g2_a21oi_1
X_3877_ _3878_/C _3895_/A _3902_/B _3636_/A VPWR VGND sg13g2_a21oi_1
X_2828_ _2828_/Y _2819_/A _3386_/B _2880_/B1 VPWR VGND sg13g2_o21ai_1
X_2759_ _2759_/Y _2743_/X _3074_/A _2744_/X VPWR VGND sg13g2_a21oi_1
X_4429_ _4460_/B _3338_/Y _3706_/B _3856_/A VPWR VGND sg13g2_a21oi_1
Xfanout400 _4218_/A2 _3135_/A2 VPWR VGND sg13g2_buf_1
Xfanout411 _3244_/A1 _4194_/A1 VPWR VGND sg13g2_buf_1
Xfanout422 _3239_/A _3254_/A VPWR VGND sg13g2_buf_1
XFILLER_48_58 VPWR VGND sg13g2_fill_2
Xfanout433 _3464_/B _3556_/B1 VPWR VGND sg13g2_buf_1
Xfanout444 _3400_/A2 _3556_/A2 VPWR VGND sg13g2_buf_2
Xfanout455 _3684_/B1 _3583_/B1 VPWR VGND sg13g2_buf_1
Xfanout466 _3004_/A2 _3546_/A2 VPWR VGND sg13g2_buf_1
Xfanout477 _2938_/B _3620_/B VPWR VGND sg13g2_buf_1
Xfanout488 _4210_/A1 _2669_/Y VPWR VGND sg13g2_buf_1
Xfanout499 _3644_/B _3627_/B VPWR VGND sg13g2_buf_1
XFILLER_74_615 VPWR VGND sg13g2_fill_2
XFILLER_74_604 VPWR VGND sg13g2_fill_2
XFILLER_58_199 VPWR VGND sg13g2_fill_2
XFILLER_42_545 VPWR VGND sg13g2_fill_2
XFILLER_10_442 VPWR VGND sg13g2_decap_8
XFILLER_22_280 VPWR VGND sg13g2_decap_8
XFILLER_6_457 VPWR VGND sg13g2_decap_8
XFILLER_77_475 VPWR VGND sg13g2_fill_1
XFILLER_77_464 VPWR VGND sg13g2_decap_8
XFILLER_45_350 VPWR VGND sg13g2_fill_1
XFILLER_45_383 VPWR VGND sg13g2_decap_4
XFILLER_33_556 VPWR VGND sg13g2_decap_8
X_4780_ _4781_/B _5209_/Q _4787_/D hold886/X VPWR VGND sg13g2_a21o_1
X_3800_ _3800_/Y _3358_/Y _3744_/Y _3823_/A VPWR VGND sg13g2_a21oi_1
XFILLER_60_342 VPWR VGND sg13g2_decap_4
X_3731_ _3733_/B _3731_/A _3731_/B _3731_/C VPWR VGND sg13g2_nor3_1
XFILLER_9_251 VPWR VGND sg13g2_decap_8
XFILLER_9_240 VPWR VGND sg13g2_fill_1
Xclkload10 clkload10/Y _5426_/CLK VPWR VGND sg13g2_inv_1
X_3662_ _3893_/C _3662_/A VPWR VGND sg13g2_inv_1
X_5401_ _5401_/Q clkload7/A _5401_/D _5141_/Y VPWR VGND sg13g2_dfrbpq_1
X_3593_ _3593_/Y _5384_/Q _3676_/A2 _3674_/A2 _5320_/Q _3592_/Y VPWR VGND sg13g2_a221oi_1
X_2613_ _2613_/Y _2613_/A VPWR VGND sg13g2_inv_1
X_5332_ _5332_/Q _5435_/CLK _5332_/D _5072_/Y VPWR VGND sg13g2_dfrbpq_1
X_2544_ _2544_/Y _2544_/A VPWR VGND sg13g2_inv_1
XFILLER_48_0 VPWR VGND sg13g2_decap_8
XFILLER_5_490 VPWR VGND sg13g2_decap_8
X_5263_ _5263_/Q _5427_/CLK _5263_/D _5003_/Y VPWR VGND sg13g2_dfrbpq_1
X_5194_ _5194_/Q clkload2/A _5194_/D _4934_/Y VPWR VGND sg13g2_dfrbpq_1
X_4214_ _4215_/D _4433_/A _4207_/B _4205_/Y VPWR VGND sg13g2_a21oi_1
XFILLER_68_431 VPWR VGND sg13g2_decap_8
X_4145_ _4474_/C _4131_/Y _4145_/B _4145_/C VPWR VGND sg13g2_nand3b_1
XFILLER_56_604 VPWR VGND sg13g2_decap_4
XFILLER_55_125 VPWR VGND sg13g2_decap_4
X_4076_ _4133_/B _4132_/B _4132_/C _4132_/A VPWR VGND sg13g2_o21ai_1
X_3027_ _3268_/B _3027_/A _3027_/B _3027_/C VPWR VGND sg13g2_nor3_1
XFILLER_51_353 VPWR VGND sg13g2_decap_4
X_4978_ _4978_/Y _5138_/A VPWR VGND sg13g2_inv_1
Xclkload4 clkload4/Y clkload4/A VPWR VGND sg13g2_inv_16
X_3929_ _3929_/Y _3858_/A _4479_/B _3928_/Y VPWR VGND sg13g2_o21ai_1
XFILLER_3_405 VPWR VGND sg13g2_fill_1
XFILLER_3_438 VPWR VGND sg13g2_fill_1
Xfanout230 _4407_/S _4409_/S VPWR VGND sg13g2_buf_1
Xfanout241 _4329_/S _4357_/S VPWR VGND sg13g2_buf_1
XFILLER_59_79 VPWR VGND sg13g2_decap_8
XFILLER_47_604 VPWR VGND sg13g2_decap_8
Xfanout252 _4247_/S _4258_/S VPWR VGND sg13g2_buf_1
Xfanout263 _4235_/S _3321_/Y VPWR VGND sg13g2_buf_1
Xfanout274 _4041_/A _4431_/B1 VPWR VGND sg13g2_buf_1
Xfanout285 _3166_/B _3010_/X VPWR VGND sg13g2_buf_1
Xfanout296 _4796_/A _4739_/A1 VPWR VGND sg13g2_buf_1
XFILLER_75_23 VPWR VGND sg13g2_decap_8
XFILLER_46_125 VPWR VGND sg13g2_decap_8
XFILLER_46_158 VPWR VGND sg13g2_decap_8
XFILLER_74_467 VPWR VGND sg13g2_fill_1
XFILLER_15_534 VPWR VGND sg13g2_decap_8
XFILLER_42_386 VPWR VGND sg13g2_decap_4
XFILLER_6_265 VPWR VGND sg13g2_fill_2
XFILLER_38_604 VPWR VGND sg13g2_decap_8
XFILLER_37_103 VPWR VGND sg13g2_decap_8
XFILLER_65_456 VPWR VGND sg13g2_decap_8
XFILLER_52_117 VPWR VGND sg13g2_fill_2
XFILLER_52_128 VPWR VGND sg13g2_decap_4
X_4901_ _4911_/B _4901_/A _4901_/B _4901_/C VPWR VGND sg13g2_nand3_1
XFILLER_21_504 VPWR VGND sg13g2_decap_8
X_4832_ _4845_/C _4833_/C VPWR VGND sg13g2_inv_1
X_4763_ _4764_/A _4840_/A _4769_/B VPWR VGND sg13g2_nand2_1
XFILLER_60_194 VPWR VGND sg13g2_fill_1
X_4694_ _4697_/B _4694_/A _4694_/B VPWR VGND sg13g2_xor2_1
X_3714_ _3731_/C _3714_/A _3714_/B _3714_/C VPWR VGND sg13g2_nand3_1
X_3645_ _3648_/A _5321_/Q _3674_/A2 _3676_/B1 _5353_/Q _3644_/X VPWR VGND sg13g2_a221oi_1
X_3576_ _3961_/B _3435_/B _3756_/A VPWR VGND sg13g2_nand2b_1
X_5315_ _5315_/Q _5414_/CLK _5315_/D _5055_/Y VPWR VGND sg13g2_dfrbpq_1
X_5246_ _5246_/Q clkload8/A _5246_/D _4986_/Y VPWR VGND sg13g2_dfrbpq_1
XFILLER_29_604 VPWR VGND sg13g2_decap_8
X_5177_ _5177_/Q _5430_/CLK _5177_/D _4917_/Y VPWR VGND sg13g2_dfrbpq_1
X_4128_ _4255_/A _2602_/Y _4128_/A2 _4126_/Y _4127_/Y VPWR VGND sg13g2_a22oi_1
XFILLER_68_294 VPWR VGND sg13g2_decap_8
X_4059_ _4059_/Y _2607_/Y _4059_/A2 _4057_/Y _4058_/Y VPWR VGND sg13g2_a22oi_1
XFILLER_56_489 VPWR VGND sg13g2_decap_8
XFILLER_71_437 VPWR VGND sg13g2_decap_4
XFILLER_51_183 VPWR VGND sg13g2_fill_2
XFILLER_79_515 VPWR VGND sg13g2_fill_1
XFILLER_10_95 VPWR VGND sg13g2_decap_8
XFILLER_47_412 VPWR VGND sg13g2_decap_8
XFILLER_34_117 VPWR VGND sg13g2_fill_1
XFILLER_34_128 VPWR VGND sg13g2_decap_4
XFILLER_62_459 VPWR VGND sg13g2_decap_8
XFILLER_30_312 VPWR VGND sg13g2_decap_8
XFILLER_42_172 VPWR VGND sg13g2_decap_8
XFILLER_30_356 VPWR VGND sg13g2_decap_8
XFILLER_11_581 VPWR VGND sg13g2_decap_8
X_3430_ _3432_/C _5381_/Q _3676_/A2 _3674_/A2 _5317_/Q VPWR VGND sg13g2_a22oi_1
X_3361_ _3364_/A _5405_/Q _3361_/B VPWR VGND sg13g2_nand2_1
X_5100_ _5100_/Y _5135_/A VPWR VGND sg13g2_inv_1
X_5031_ _5031_/Y _5095_/A VPWR VGND sg13g2_inv_1
X_3292_ _3302_/B _3268_/C _3292_/B VPWR VGND sg13g2_nand2b_1
XFILLER_53_437 VPWR VGND sg13g2_decap_8
XFILLER_33_172 VPWR VGND sg13g2_decap_8
XFILLER_21_323 VPWR VGND sg13g2_decap_8
XFILLER_33_183 VPWR VGND sg13g2_decap_8
X_4815_ _5213_/D _4814_/A _4813_/X _4814_/Y VPWR VGND sg13g2_a21oi_1
Xrebuffer605 _5438_/A _4530_/B VPWR VGND sg13g2_buf_1
X_4746_ _4761_/B _5205_/Q _5206_/Q _5207_/Q _4746_/D VPWR VGND sg13g2_nand4_1
X_4677_ _4677_/Y _4679_/A VPWR VGND sg13g2_inv_1
X_3628_ _3631_/B _5322_/Q _3689_/A2 _3689_/B1 _5418_/Q VPWR VGND sg13g2_a22oi_1
X_3559_ _3567_/B input40/X _5452_/A _3559_/S VPWR VGND sg13g2_mux2_1
X_5229_ _5229_/Q clkload0/A _5229_/D _4969_/Y VPWR VGND sg13g2_dfrbpq_1
XFILLER_56_14 VPWR VGND sg13g2_fill_1
XFILLER_17_607 VPWR VGND sg13g2_decap_4
XFILLER_56_297 VPWR VGND sg13g2_decap_8
XFILLER_52_470 VPWR VGND sg13g2_decap_8
XFILLER_72_57 VPWR VGND sg13g2_fill_2
XFILLER_72_46 VPWR VGND sg13g2_decap_8
XFILLER_4_500 VPWR VGND sg13g2_fill_1
XFILLER_4_588 VPWR VGND sg13g2_decap_8
XFILLER_39_209 VPWR VGND sg13g2_decap_4
XFILLER_47_264 VPWR VGND sg13g2_decap_8
XFILLER_35_426 VPWR VGND sg13g2_decap_4
XFILLER_35_437 VPWR VGND sg13g2_fill_1
XFILLER_47_275 VPWR VGND sg13g2_fill_1
XFILLER_47_297 VPWR VGND sg13g2_decap_8
X_2930_ _4566_/C _2930_/A _2930_/B _2930_/C _2930_/D VPWR VGND sg13g2_nand4_1
XFILLER_62_278 VPWR VGND sg13g2_decap_4
XFILLER_15_183 VPWR VGND sg13g2_decap_8
X_4600_ _4600_/Y _2569_/Y _4641_/A _4599_/Y VPWR VGND sg13g2_o21ai_1
X_2861_ _2861_/Y _2555_/Y _3386_/B _2880_/B1 VPWR VGND sg13g2_o21ai_1
X_2792_ _2792_/Y _5270_/Q _3371_/A2 _3371_/B1 _5334_/Q _2791_/Y VPWR VGND sg13g2_a221oi_1
X_4531_ _4535_/B _4531_/A _4569_/C VPWR VGND sg13g2_or2_1
X_4462_ _4465_/C _4462_/A _4462_/B VPWR VGND sg13g2_nand2_1
XFILLER_7_85 VPWR VGND sg13g2_fill_1
XFILLER_7_393 VPWR VGND sg13g2_decap_8
XFILLER_7_382 VPWR VGND sg13g2_decap_4
X_3413_ _4198_/B _2730_/B _3413_/B VPWR VGND sg13g2_nand2b_1
X_4393_ _5263_/D _4427_/A hold675/X _4393_/S VPWR VGND sg13g2_mux2_1
XFILLER_30_0 VPWR VGND sg13g2_decap_8
X_3344_ _3346_/B _5325_/Q _3666_/B _3668_/B1 _5293_/Q VPWR VGND sg13g2_a22oi_1
X_3275_ _3275_/Y _3275_/A _4457_/B VPWR VGND sg13g2_nor2_1
X_5014_ _5014_/Y _5142_/A VPWR VGND sg13g2_inv_1
XFILLER_26_404 VPWR VGND sg13g2_fill_2
XFILLER_66_551 VPWR VGND sg13g2_decap_8
XFILLER_26_459 VPWR VGND sg13g2_decap_8
XFILLER_81_543 VPWR VGND sg13g2_fill_2
XFILLER_81_576 VPWR VGND sg13g2_decap_8
XFILLER_42_16 VPWR VGND sg13g2_fill_1
XFILLER_21_142 VPWR VGND sg13g2_fill_1
XFILLER_42_49 VPWR VGND sg13g2_decap_8
XFILLER_21_197 VPWR VGND sg13g2_decap_8
X_4729_ _4729_/Y _4729_/A _4729_/B _4730_/C VPWR VGND sg13g2_nor3_1
XFILLER_5_308 VPWR VGND sg13g2_decap_8
XFILLER_1_525 VPWR VGND sg13g2_decap_8
Xhold872 _2631_/A _5221_/Q VPWR VGND sg13g2_dlygate4sd3_1
Xhold861 _4862_/B _4860_/B VPWR VGND sg13g2_dlygate4sd3_1
Xhold850 _4817_/B _5214_/Q VPWR VGND sg13g2_dlygate4sd3_1
Xhold883 _4684_/B _5200_/Q VPWR VGND sg13g2_dlygate4sd3_1
XFILLER_49_529 VPWR VGND sg13g2_decap_8
XFILLER_67_68 VPWR VGND sg13g2_decap_8
XFILLER_57_551 VPWR VGND sg13g2_decap_8
XFILLER_57_584 VPWR VGND sg13g2_decap_8
XFILLER_12_164 VPWR VGND sg13g2_decap_4
XFILLER_0_591 VPWR VGND sg13g2_decap_8
X_3060_ _3061_/A _3060_/A _3060_/B _3060_/C _3060_/D VPWR VGND sg13g2_nor4_1
XFILLER_48_595 VPWR VGND sg13g2_decap_8
XFILLER_75_370 VPWR VGND sg13g2_decap_8
XFILLER_63_510 VPWR VGND sg13g2_decap_8
XFILLER_35_245 VPWR VGND sg13g2_decap_8
XFILLER_75_392 VPWR VGND sg13g2_decap_8
XFILLER_63_554 VPWR VGND sg13g2_fill_2
XFILLER_35_267 VPWR VGND sg13g2_fill_1
XFILLER_16_481 VPWR VGND sg13g2_decap_8
X_3962_ _3985_/A _4088_/B _3962_/B _3962_/C VPWR VGND sg13g2_nand3_1
XFILLER_31_440 VPWR VGND sg13g2_decap_8
X_3893_ _3894_/B _3893_/A _3893_/B _3893_/C VPWR VGND sg13g2_nor3_1
X_2913_ _2915_/D _3210_/B _3210_/C _3233_/A _3025_/B VPWR VGND sg13g2_a22oi_1
XFILLER_31_473 VPWR VGND sg13g2_decap_8
XFILLER_31_484 VPWR VGND sg13g2_fill_1
X_2844_ _2844_/Y _5265_/Q _3371_/A2 _3371_/B1 _5329_/Q _2843_/Y VPWR VGND sg13g2_a221oi_1
XFILLER_78_0 VPWR VGND sg13g2_decap_8
X_4514_ _5180_/D hold773/X _4255_/A _4514_/S VPWR VGND sg13g2_mux2_1
X_2775_ _2776_/D _5237_/Q _3677_/B VPWR VGND sg13g2_nand2_1
X_4445_ _4452_/C _4445_/A _4445_/B _4445_/C _4445_/D VPWR VGND sg13g2_nor4_1
X_4376_ _5279_/D _4335_/A hold664/X _4393_/S VPWR VGND sg13g2_mux2_1
X_3327_ _4444_/A _3765_/A VPWR VGND sg13g2_inv_1
XFILLER_37_38 VPWR VGND sg13g2_fill_2
X_3258_ _3261_/B _4212_/A1 _3248_/A _3257_/Y VPWR VGND sg13g2_o21ai_1
X_3189_ _3190_/D _4210_/A1 _2916_/A _3188_/Y VPWR VGND sg13g2_o21ai_1
XFILLER_26_267 VPWR VGND sg13g2_decap_4
XFILLER_41_215 VPWR VGND sg13g2_decap_8
XFILLER_81_373 VPWR VGND sg13g2_fill_1
XFILLER_53_37 VPWR VGND sg13g2_decap_8
XFILLER_10_602 VPWR VGND sg13g2_fill_2
XFILLER_22_440 VPWR VGND sg13g2_decap_8
XFILLER_10_635 VPWR VGND sg13g2_decap_8
XFILLER_6_617 VPWR VGND sg13g2_decap_4
XFILLER_5_116 VPWR VGND sg13g2_decap_8
Xhold680 hold680/X _5384_/Q VPWR VGND sg13g2_dlygate4sd3_1
XFILLER_78_45 VPWR VGND sg13g2_decap_8
XFILLER_1_366 VPWR VGND sg13g2_fill_1
Xhold691 hold691/X _5238_/Q VPWR VGND sg13g2_dlygate4sd3_1
XFILLER_77_624 VPWR VGND sg13g2_decap_8
XFILLER_49_348 VPWR VGND sg13g2_fill_1
XFILLER_45_521 VPWR VGND sg13g2_decap_8
XFILLER_76_178 VPWR VGND sg13g2_decap_8
XFILLER_64_318 VPWR VGND sg13g2_fill_2
XFILLER_27_60 VPWR VGND sg13g2_decap_8
XFILLER_17_267 VPWR VGND sg13g2_fill_1
Xclkbuf_2_0__f_clk clkbuf_2_0__f_clk/X clkbuf_0_clk/X VPWR VGND sg13g2_buf_16
XFILLER_72_373 VPWR VGND sg13g2_decap_8
XFILLER_60_546 VPWR VGND sg13g2_decap_8
XFILLER_13_451 VPWR VGND sg13g2_fill_2
XFILLER_13_495 VPWR VGND sg13g2_decap_4
Xoutput207 io_wdata[19] _5455_/X VPWR VGND sg13g2_buf_1
X_2560_ _2789_/A _2560_/A VPWR VGND sg13g2_inv_1
Xoutput218 io_wdata[29] _5465_/X VPWR VGND sg13g2_buf_1
Xoutput229 io_wr _4523_/Y VPWR VGND sg13g2_buf_1
X_4230_ _5396_/D hold809/X _4351_/A _4235_/S VPWR VGND sg13g2_mux2_1
X_4161_ _4174_/B _4433_/A _4167_/B VPWR VGND sg13g2_nand2_1
XFILLER_68_613 VPWR VGND sg13g2_decap_8
X_4092_ _4102_/A _4159_/A _4092_/B _4092_/C VPWR VGND sg13g2_nor3_1
X_3112_ _3112_/Y _4712_/A _3135_/A2 _3154_/B1 VPWR VGND sg13g2_a21oi_1
XFILLER_36_521 VPWR VGND sg13g2_decap_8
X_3043_ _3046_/A _3036_/Y _3042_/Y _3041_/Y VPWR VGND sg13g2_o21ai_1
XFILLER_36_532 VPWR VGND sg13g2_fill_1
XFILLER_48_392 VPWR VGND sg13g2_fill_1
XFILLER_51_524 VPWR VGND sg13g2_decap_8
X_4994_ _4994_/Y _5153_/A VPWR VGND sg13g2_inv_1
XFILLER_23_248 VPWR VGND sg13g2_decap_4
X_3945_ _3945_/Y _3945_/A _3945_/B VPWR VGND sg13g2_xnor2_1
X_3876_ _3885_/A _4461_/A _3876_/B VPWR VGND sg13g2_nor2_1
X_2827_ _2827_/Y _5426_/Q _3397_/B _2879_/A2 _5298_/Q _2826_/Y VPWR VGND sg13g2_a221oi_1
X_2758_ _3074_/A _3101_/A _3018_/A VPWR VGND sg13g2_and2_1
X_4428_ _5231_/D _2564_/Y _4427_/B _4427_/Y VPWR VGND sg13g2_a21oi_1
X_2689_ _2689_/Y _2704_/C _2704_/B VPWR VGND sg13g2_nor2_1
Xfanout401 _3135_/A2 _3318_/A2 VPWR VGND sg13g2_buf_1
Xfanout412 _4194_/A1 _3134_/A1 VPWR VGND sg13g2_buf_1
Xfanout423 _4433_/A _3209_/A1 VPWR VGND sg13g2_buf_1
XFILLER_48_37 VPWR VGND sg13g2_fill_2
Xfanout434 _3371_/B1 _3400_/B1 VPWR VGND sg13g2_buf_2
Xfanout445 _3556_/A2 _2720_/Y VPWR VGND sg13g2_buf_1
Xfanout456 _3363_/B1 _3003_/B1 VPWR VGND sg13g2_buf_1
X_4359_ _5295_/D _4427_/A hold665/X _4359_/S VPWR VGND sg13g2_mux2_1
Xfanout467 _3546_/A2 _2700_/Y VPWR VGND sg13g2_buf_1
Xfanout478 _3620_/B _2691_/X VPWR VGND sg13g2_buf_1
Xfanout489 _4068_/A _3210_/A VPWR VGND sg13g2_buf_1
XFILLER_46_318 VPWR VGND sg13g2_decap_4
XFILLER_73_126 VPWR VGND sg13g2_decap_8
XFILLER_27_521 VPWR VGND sg13g2_decap_8
XFILLER_27_565 VPWR VGND sg13g2_fill_2
XFILLER_27_587 VPWR VGND sg13g2_decap_8
XFILLER_42_513 VPWR VGND sg13g2_decap_8
XFILLER_64_69 VPWR VGND sg13g2_decap_8
XFILLER_81_181 VPWR VGND sg13g2_decap_8
XFILLER_14_259 VPWR VGND sg13g2_fill_2
XFILLER_42_568 VPWR VGND sg13g2_fill_2
XFILLER_13_40 VPWR VGND sg13g2_decap_8
XFILLER_80_68 VPWR VGND sg13g2_decap_4
XFILLER_13_73 VPWR VGND sg13g2_decap_8
XFILLER_2_642 VPWR VGND sg13g2_decap_8
XFILLER_8_0 VPWR VGND sg13g2_decap_4
XFILLER_29_9 VPWR VGND sg13g2_fill_1
XFILLER_77_421 VPWR VGND sg13g2_decap_4
XFILLER_37_318 VPWR VGND sg13g2_decap_8
XFILLER_37_329 VPWR VGND sg13g2_fill_2
XFILLER_64_115 VPWR VGND sg13g2_fill_1
XFILLER_38_92 VPWR VGND sg13g2_decap_8
XFILLER_18_587 VPWR VGND sg13g2_decap_8
XFILLER_60_365 VPWR VGND sg13g2_decap_8
X_3730_ _3730_/Y _4132_/B _4132_/C VPWR VGND sg13g2_nor2_1
XFILLER_13_281 VPWR VGND sg13g2_fill_2
X_3661_ _3662_/A _3916_/B _3659_/Y _3660_/Y VPWR VGND sg13g2_a21oi_1
X_5400_ _5400_/Q _5432_/CLK _5400_/D _5140_/Y VPWR VGND sg13g2_dfrbpq_1
Xclkload11 clkload11/Y _5430_/CLK VPWR VGND sg13g2_inv_1
X_3592_ _3592_/Y _2539_/Y _3443_/B _3692_/A2 VPWR VGND sg13g2_o21ai_1
X_2612_ _2612_/Y _2612_/A VPWR VGND sg13g2_inv_1
X_5331_ _5331_/Q _5426_/CLK _5331_/D _5071_/Y VPWR VGND sg13g2_dfrbpq_1
X_2543_ _2826_/A _2543_/A VPWR VGND sg13g2_inv_1
X_5262_ _5262_/Q clkload2/A _5262_/D _5002_/Y VPWR VGND sg13g2_dfrbpq_1
X_5193_ _5193_/Q clkload3/A _5193_/D _4933_/Y VPWR VGND sg13g2_dfrbpq_1
X_4213_ _4215_/C _4213_/A _4213_/B _4213_/C _4213_/D VPWR VGND sg13g2_nor4_1
X_4144_ _4145_/C _4433_/B _4135_/Y _4143_/Y _4441_/A _4142_/Y VPWR VGND sg13g2_a221oi_1
XFILLER_68_487 VPWR VGND sg13g2_decap_4
X_4075_ _4081_/B _4073_/Y _4075_/B VPWR VGND sg13g2_nand2b_1
X_3026_ _3033_/A _3253_/A _3026_/B VPWR VGND sg13g2_nor2_1
XFILLER_71_608 VPWR VGND sg13g2_fill_2
XFILLER_24_546 VPWR VGND sg13g2_fill_1
XFILLER_34_28 VPWR VGND sg13g2_decap_8
XFILLER_36_395 VPWR VGND sg13g2_decap_8
XFILLER_51_321 VPWR VGND sg13g2_fill_1
XFILLER_11_218 VPWR VGND sg13g2_fill_1
XFILLER_11_229 VPWR VGND sg13g2_decap_4
X_4977_ _4977_/Y _5138_/A VPWR VGND sg13g2_inv_1
Xclkload5 clkload5/Y clkload5/A VPWR VGND sg13g2_inv_1
X_3928_ _3928_/Y _2617_/Y _3838_/B _3064_/A VPWR VGND sg13g2_a21oi_1
X_3859_ _3859_/Y input85/X _3838_/B _3065_/Y VPWR VGND sg13g2_a21oi_1
XFILLER_1_7 VPWR VGND sg13g2_decap_4
Xfanout231 _4409_/S _4410_/S VPWR VGND sg13g2_buf_1
XFILLER_59_410 VPWR VGND sg13g2_fill_1
Xfanout242 _4351_/B _4350_/S VPWR VGND sg13g2_buf_1
Xfanout253 _4258_/S _4238_/Y VPWR VGND sg13g2_buf_1
Xfanout264 _4509_/S _4514_/S VPWR VGND sg13g2_buf_1
XFILLER_59_443 VPWR VGND sg13g2_fill_2
XFILLER_59_432 VPWR VGND sg13g2_decap_8
Xfanout275 _4133_/A _4431_/B1 VPWR VGND sg13g2_buf_1
Xfanout286 _4069_/B2 _4211_/B2 VPWR VGND sg13g2_buf_1
Xfanout297 _4739_/A1 _4839_/A VPWR VGND sg13g2_buf_1
XFILLER_75_68 VPWR VGND sg13g2_fill_2
XFILLER_74_446 VPWR VGND sg13g2_fill_1
XFILLER_62_619 VPWR VGND sg13g2_decap_8
XFILLER_61_107 VPWR VGND sg13g2_fill_1
XFILLER_42_321 VPWR VGND sg13g2_decap_8
XFILLER_15_557 VPWR VGND sg13g2_fill_1
XFILLER_30_538 VPWR VGND sg13g2_fill_2
XFILLER_6_244 VPWR VGND sg13g2_decap_8
XFILLER_2_461 VPWR VGND sg13g2_fill_1
XFILLER_34_7 VPWR VGND sg13g2_decap_8
XFILLER_65_446 VPWR VGND sg13g2_fill_2
XFILLER_65_435 VPWR VGND sg13g2_decap_8
X_4900_ _4900_/Y _5222_/Q _4901_/C _4901_/B VPWR VGND sg13g2_a21oi_1
X_4831_ _4833_/C _4831_/A _4831_/B VPWR VGND sg13g2_xnor2_1
XFILLER_33_376 VPWR VGND sg13g2_fill_2
X_4762_ _4769_/B _4765_/B VPWR VGND sg13g2_inv_1
X_4693_ _4719_/D _5199_/Q _5200_/Q _5201_/Q _4693_/D VPWR VGND sg13g2_nand4_1
X_3713_ _3733_/A _4048_/B _4030_/A _3713_/C VPWR VGND sg13g2_nor3_1
X_3644_ _3644_/X _5189_/Q _3644_/B VPWR VGND sg13g2_and2_1
X_3575_ _3991_/B _3478_/Y _4019_/C _4016_/B VPWR VGND sg13g2_o21ai_1
X_5314_ _5314_/Q clkload7/A _5314_/D _5054_/Y VPWR VGND sg13g2_dfrbpq_1
X_5245_ _5245_/Q _5426_/CLK _5245_/D _4985_/Y VPWR VGND sg13g2_dfrbpq_1
X_5176_ _5176_/Q _5434_/CLK _5176_/D _2632_/Y VPWR VGND sg13g2_dfrbpq_1
XFILLER_68_273 VPWR VGND sg13g2_decap_8
X_4127_ _4127_/Y _4394_/B _2666_/C _4128_/A2 VPWR VGND sg13g2_a21oi_1
X_4058_ _4058_/Y _4603_/A1 _2666_/C _4059_/A2 VPWR VGND sg13g2_a21oi_1
XFILLER_71_416 VPWR VGND sg13g2_decap_8
X_3009_ _3009_/Y _3057_/A _4185_/B _3010_/C _3010_/D VPWR VGND sg13g2_nor4_1
XFILLER_36_192 VPWR VGND sg13g2_fill_2
XFILLER_52_630 VPWR VGND sg13g2_decap_8
XFILLER_12_527 VPWR VGND sg13g2_fill_2
XFILLER_51_162 VPWR VGND sg13g2_decap_8
XFILLER_10_41 VPWR VGND sg13g2_decap_8
XFILLER_10_74 VPWR VGND sg13g2_decap_8
XFILLER_19_50 VPWR VGND sg13g2_fill_1
XFILLER_35_608 VPWR VGND sg13g2_fill_1
XFILLER_47_457 VPWR VGND sg13g2_decap_8
XFILLER_62_438 VPWR VGND sg13g2_decap_8
XFILLER_62_416 VPWR VGND sg13g2_fill_1
XFILLER_55_490 VPWR VGND sg13g2_fill_1
XFILLER_15_387 VPWR VGND sg13g2_decap_8
XFILLER_42_151 VPWR VGND sg13g2_decap_8
XFILLER_70_493 VPWR VGND sg13g2_decap_4
X_3360_ _3360_/Y _3368_/A _2819_/B _3365_/B1 VPWR VGND sg13g2_o21ai_1
X_5030_ _5030_/Y _5095_/A VPWR VGND sg13g2_inv_1
X_3291_ _3292_/B _3289_/A _3028_/Y _4131_/A VPWR VGND sg13g2_a21oi_1
XFILLER_78_593 VPWR VGND sg13g2_fill_2
XFILLER_65_232 VPWR VGND sg13g2_decap_4
XFILLER_26_619 VPWR VGND sg13g2_decap_4
XFILLER_38_457 VPWR VGND sg13g2_decap_8
XFILLER_38_468 VPWR VGND sg13g2_fill_1
XFILLER_65_287 VPWR VGND sg13g2_fill_1
XFILLER_65_276 VPWR VGND sg13g2_decap_8
XFILLER_18_181 VPWR VGND sg13g2_decap_8
XFILLER_33_151 VPWR VGND sg13g2_decap_8
XFILLER_80_279 VPWR VGND sg13g2_fill_2
X_4814_ _4814_/Y _4814_/A _4814_/B VPWR VGND sg13g2_nor2_1
Xrebuffer606 _4568_/B _2811_/Y VPWR VGND sg13g2_buf_2
X_4745_ _5206_/D _4741_/Y _4744_/Y _4745_/S VPWR VGND sg13g2_mux2_1
X_4676_ _4679_/A _4676_/A _4676_/B VPWR VGND sg13g2_nand2_1
X_3627_ _3631_/A _5190_/Q _3627_/B VPWR VGND sg13g2_nand2_1
X_3558_ _5452_/A _3555_/Y _3556_/Y _3557_/Y VPWR VGND sg13g2_a21oi_1
X_3489_ _3564_/A _3489_/A _3958_/A VPWR VGND sg13g2_nor2_1
X_5228_ _5228_/Q clkload0/A _5228_/D _4968_/Y VPWR VGND sg13g2_dfrbpq_1
X_5159_ _5159_/Y _5159_/A VPWR VGND sg13g2_inv_1
XFILLER_29_479 VPWR VGND sg13g2_fill_2
XFILLER_56_48 VPWR VGND sg13g2_decap_8
XFILLER_44_427 VPWR VGND sg13g2_fill_2
XFILLER_56_276 VPWR VGND sg13g2_decap_8
XFILLER_24_140 VPWR VGND sg13g2_decap_8
XFILLER_24_184 VPWR VGND sg13g2_fill_1
XFILLER_21_51 VPWR VGND sg13g2_fill_2
XFILLER_4_567 VPWR VGND sg13g2_decap_8
XFILLER_79_346 VPWR VGND sg13g2_fill_2
XFILLER_35_405 VPWR VGND sg13g2_decap_8
XFILLER_47_243 VPWR VGND sg13g2_decap_8
XFILLER_75_585 VPWR VGND sg13g2_decap_8
XFILLER_43_460 VPWR VGND sg13g2_decap_8
XFILLER_43_471 VPWR VGND sg13g2_fill_1
X_2860_ _2860_/Y _5296_/Q _2879_/A2 _3399_/B1 _5392_/Q _2859_/X VPWR VGND sg13g2_a221oi_1
XFILLER_62_80 VPWR VGND sg13g2_decap_8
X_2791_ _2791_/Y _2782_/A _3386_/B _2880_/B1 VPWR VGND sg13g2_o21ai_1
X_4530_ _4569_/C _4530_/A _4530_/B VPWR VGND sg13g2_or2_1
X_4461_ _4466_/A _4461_/A _4462_/B VPWR VGND sg13g2_nor2_1
XFILLER_7_97 VPWR VGND sg13g2_fill_1
XFILLER_7_361 VPWR VGND sg13g2_decap_8
X_3412_ _3415_/A _3406_/B _4206_/B VPWR VGND sg13g2_nand2b_1
X_4392_ _5264_/D _4280_/A hold735/X _4393_/S VPWR VGND sg13g2_mux2_1
X_3343_ _3346_/A _5389_/Q _3581_/B _3668_/A2 _5357_/Q VPWR VGND sg13g2_a22oi_1
X_3274_ _3274_/Y _4159_/A _3274_/B VPWR VGND sg13g2_nor2_1
XFILLER_38_221 VPWR VGND sg13g2_fill_2
X_5013_ _5013_/Y _5134_/A VPWR VGND sg13g2_inv_1
XFILLER_66_530 VPWR VGND sg13g2_decap_8
XFILLER_26_438 VPWR VGND sg13g2_decap_8
XFILLER_66_596 VPWR VGND sg13g2_fill_1
XFILLER_66_574 VPWR VGND sg13g2_fill_2
Xclkbuf_leaf_18_clk clkload8/A clkbuf_leaf_3_clk/A VPWR VGND sg13g2_buf_8
XFILLER_21_121 VPWR VGND sg13g2_decap_8
XFILLER_22_622 VPWR VGND sg13g2_fill_2
XFILLER_21_176 VPWR VGND sg13g2_decap_8
X_2989_ _3191_/B _2992_/B _3238_/A VPWR VGND sg13g2_and2_1
X_4728_ _4730_/C _4728_/A _4728_/B VPWR VGND sg13g2_or2_1
X_4659_ _4659_/Y _4660_/A _4660_/B VPWR VGND sg13g2_nor2_1
Xhold873 _2627_/A _5207_/Q VPWR VGND sg13g2_dlygate4sd3_1
Xhold862 _4674_/A _5199_/Q VPWR VGND sg13g2_dlygate4sd3_1
Xhold851 hold851/X _4816_/Y VPWR VGND sg13g2_dlygate4sd3_1
Xhold840 hold840/X _5397_/Q VPWR VGND sg13g2_dlygate4sd3_1
Xhold884 _4686_/B _4685_/X VPWR VGND sg13g2_dlygate4sd3_1
XFILLER_76_338 VPWR VGND sg13g2_fill_2
XFILLER_72_533 VPWR VGND sg13g2_decap_4
XFILLER_25_471 VPWR VGND sg13g2_decap_8
XFILLER_32_83 VPWR VGND sg13g2_fill_1
XFILLER_79_143 VPWR VGND sg13g2_fill_2
XFILLER_67_305 VPWR VGND sg13g2_decap_8
XFILLER_0_570 VPWR VGND sg13g2_decap_8
XFILLER_57_80 VPWR VGND sg13g2_decap_8
XFILLER_48_574 VPWR VGND sg13g2_fill_1
X_3961_ _3962_/C _3961_/A _3961_/B _3992_/B VPWR VGND sg13g2_nand3_1
XFILLER_63_588 VPWR VGND sg13g2_decap_8
XFILLER_16_471 VPWR VGND sg13g2_decap_4
XFILLER_50_216 VPWR VGND sg13g2_decap_8
X_2912_ _2918_/A _3248_/A _2912_/B _2912_/C VPWR VGND sg13g2_or3_1
X_3892_ _3905_/A _3893_/B _3862_/Y _3871_/A VPWR VGND sg13g2_a21oi_1
X_2843_ _2843_/Y _2554_/Y _3386_/B _2880_/B1 VPWR VGND sg13g2_o21ai_1
X_2774_ _2776_/C _5365_/Q _2927_/A2 _3369_/B1 _5397_/Q VPWR VGND sg13g2_a22oi_1
X_4513_ _5181_/D hold734/X _4253_/A _4518_/S VPWR VGND sg13g2_mux2_1
Xclkbuf_leaf_7_clk _5426_/CLK clkbuf_leaf_9_clk/A VPWR VGND sg13g2_buf_8
X_4444_ _4445_/D _4444_/A _4444_/B VPWR VGND sg13g2_nand2_1
X_4375_ _5280_/D _4255_/A hold769/X _4375_/S VPWR VGND sg13g2_mux2_1
X_3326_ _3326_/Y _3326_/A _3326_/B _3326_/C _3326_/D VPWR VGND sg13g2_nand4_1
XFILLER_58_327 VPWR VGND sg13g2_decap_8
X_3257_ _3257_/Y _4434_/A _4209_/A1 _4209_/B1 _3233_/A VPWR VGND sg13g2_a22oi_1
XFILLER_39_563 VPWR VGND sg13g2_decap_8
X_3188_ _3188_/Y _3187_/A _3040_/A _4094_/B1 VPWR VGND sg13g2_o21ai_1
XFILLER_66_393 VPWR VGND sg13g2_fill_1
XFILLER_14_419 VPWR VGND sg13g2_decap_8
XFILLER_22_485 VPWR VGND sg13g2_decap_4
Xhold670 hold670/X _5348_/Q VPWR VGND sg13g2_dlygate4sd3_1
Xhold681 hold681/X _5244_/Q VPWR VGND sg13g2_dlygate4sd3_1
Xhold692 hold692/X _5308_/Q VPWR VGND sg13g2_dlygate4sd3_1
XFILLER_78_68 VPWR VGND sg13g2_fill_1
XFILLER_77_647 VPWR VGND sg13g2_decap_4
XFILLER_57_360 VPWR VGND sg13g2_fill_1
XFILLER_32_216 VPWR VGND sg13g2_decap_8
XFILLER_32_227 VPWR VGND sg13g2_fill_2
XFILLER_32_238 VPWR VGND sg13g2_decap_4
XFILLER_60_525 VPWR VGND sg13g2_decap_8
XFILLER_13_430 VPWR VGND sg13g2_fill_1
XFILLER_13_474 VPWR VGND sg13g2_decap_8
XFILLER_43_60 VPWR VGND sg13g2_decap_8
XFILLER_9_445 VPWR VGND sg13g2_decap_8
Xoutput208 io_wdata[1] _5437_/X VPWR VGND sg13g2_buf_1
Xoutput219 io_wdata[2] _5438_/X VPWR VGND sg13g2_buf_1
XFILLER_57_6 VPWR VGND sg13g2_fill_1
XFILLER_4_54 VPWR VGND sg13g2_fill_2
XFILLER_4_65 VPWR VGND sg13g2_decap_4
X_4160_ _4167_/B _4160_/A _4160_/B VPWR VGND sg13g2_xnor2_1
X_3111_ _3111_/Y _4217_/A1 _3109_/Y _3110_/Y VPWR VGND sg13g2_o21ai_1
X_4091_ _4092_/C _4448_/D _4114_/B _4095_/B VPWR VGND sg13g2_a21oi_1
XFILLER_36_500 VPWR VGND sg13g2_decap_8
X_3042_ _3042_/Y _3184_/B _3161_/A VPWR VGND sg13g2_nand2_1
XFILLER_67_179 VPWR VGND sg13g2_decap_8
XFILLER_55_308 VPWR VGND sg13g2_fill_2
XFILLER_51_547 VPWR VGND sg13g2_fill_1
X_4993_ _4993_/Y _5160_/A VPWR VGND sg13g2_inv_1
X_3944_ _3949_/A _4461_/A _3935_/Y _3943_/Y VPWR VGND sg13g2_o21ai_1
X_3875_ _3886_/C _4462_/A _3876_/B VPWR VGND sg13g2_nand2_1
X_2826_ _2826_/Y _2826_/A _3443_/B VPWR VGND sg13g2_nor2_1
X_2757_ _3018_/A _4712_/A _5446_/A _3392_/S VPWR VGND sg13g2_mux2_1
X_2688_ _2688_/Y _4238_/C _2688_/B VPWR VGND sg13g2_nor2_1
X_4427_ _4427_/Y _4427_/A _4427_/B VPWR VGND sg13g2_nor2_1
XFILLER_48_16 VPWR VGND sg13g2_decap_4
Xfanout402 _3318_/A2 _2657_/Y VPWR VGND sg13g2_buf_1
Xfanout413 _3134_/A1 _2679_/X VPWR VGND sg13g2_buf_1
Xfanout424 _4447_/A1 _2649_/Y VPWR VGND sg13g2_buf_1
Xfanout435 _3400_/B1 _3556_/B1 VPWR VGND sg13g2_buf_4
Xfanout446 _3674_/A2 _3689_/A2 VPWR VGND sg13g2_buf_1
Xfanout457 _3003_/B1 _3583_/B1 VPWR VGND sg13g2_buf_1
X_4358_ _5296_/D _4280_/A hold818/X _4359_/S VPWR VGND sg13g2_mux2_1
XFILLER_58_102 VPWR VGND sg13g2_decap_8
Xfanout468 _3666_/B _3683_/A2 VPWR VGND sg13g2_buf_1
Xfanout479 _4020_/A _4048_/A VPWR VGND sg13g2_buf_1
X_4289_ _5354_/D _3890_/Y hold696/X _4294_/S VPWR VGND sg13g2_mux2_1
X_3309_ _3309_/Y _4485_/A _4162_/A _3308_/Y VPWR VGND sg13g2_o21ai_1
XFILLER_58_135 VPWR VGND sg13g2_decap_8
XFILLER_27_544 VPWR VGND sg13g2_fill_2
XFILLER_39_382 VPWR VGND sg13g2_decap_8
XFILLER_64_37 VPWR VGND sg13g2_decap_8
XFILLER_54_352 VPWR VGND sg13g2_decap_8
XFILLER_81_160 VPWR VGND sg13g2_decap_8
XFILLER_14_249 VPWR VGND sg13g2_decap_8
XFILLER_80_47 VPWR VGND sg13g2_decap_8
XFILLER_10_477 VPWR VGND sg13g2_decap_8
XFILLER_6_437 VPWR VGND sg13g2_decap_8
XFILLER_1_120 VPWR VGND sg13g2_fill_2
XFILLER_1_164 VPWR VGND sg13g2_fill_1
XFILLER_77_444 VPWR VGND sg13g2_fill_1
XFILLER_77_433 VPWR VGND sg13g2_decap_8
XFILLER_38_60 VPWR VGND sg13g2_fill_2
XFILLER_18_533 VPWR VGND sg13g2_decap_8
XFILLER_33_514 VPWR VGND sg13g2_decap_8
X_3660_ _3660_/Y _4445_/A _3660_/B VPWR VGND sg13g2_nor2_1
Xclkload12 clkload12/X _5425_/CLK VPWR VGND sg13g2_buf_8
X_3591_ _3591_/Y _5288_/Q _3674_/B1 _3676_/B1 _5352_/Q _3590_/X VPWR VGND sg13g2_a221oi_1
X_2611_ _2722_/A _2723_/B VPWR VGND sg13g2_inv_1
XFILLER_70_91 VPWR VGND sg13g2_fill_2
XFILLER_62_4 VPWR VGND sg13g2_decap_8
X_5330_ _5330_/Q _5426_/CLK _5330_/D _5070_/Y VPWR VGND sg13g2_dfrbpq_1
X_2542_ _2894_/A _2542_/A VPWR VGND sg13g2_inv_1
X_5261_ _5261_/Q clkload0/A _5261_/D _5001_/Y VPWR VGND sg13g2_dfrbpq_1
X_4212_ _4213_/D _4212_/A1 _3405_/Y _4211_/Y VPWR VGND sg13g2_o21ai_1
X_5192_ _5192_/Q clkload4/A _5192_/D _4932_/Y VPWR VGND sg13g2_dfrbpq_1
X_4143_ _4143_/Y _4143_/A _4143_/B VPWR VGND sg13g2_xnor2_1
X_4074_ _4075_/B _4074_/A1 _4065_/Y _4067_/Y _3120_/A VPWR VGND sg13g2_a22oi_1
XFILLER_68_466 VPWR VGND sg13g2_fill_2
X_3025_ _3201_/B _3025_/A _3025_/B VPWR VGND sg13g2_nor2_1
XFILLER_36_352 VPWR VGND sg13g2_fill_2
XFILLER_24_514 VPWR VGND sg13g2_decap_4
XFILLER_24_525 VPWR VGND sg13g2_decap_8
XFILLER_63_171 VPWR VGND sg13g2_fill_2
XFILLER_51_377 VPWR VGND sg13g2_decap_8
X_4976_ _4976_/Y _5138_/A VPWR VGND sg13g2_inv_1
XFILLER_32_591 VPWR VGND sg13g2_decap_8
X_3927_ _4479_/B _3927_/A _3927_/B _3927_/C _3927_/D VPWR VGND sg13g2_nand4_1
Xclkload6 clkload6/X clkload6/A VPWR VGND sg13g2_buf_8
X_3858_ _3858_/X _3858_/A _4478_/A VPWR VGND sg13g2_or2_1
X_3789_ _3790_/C _4020_/A _3746_/A _3788_/Y VPWR VGND sg13g2_o21ai_1
X_2809_ _2811_/C _5428_/Q _2841_/B _3371_/B1 _5332_/Q VPWR VGND sg13g2_a22oi_1
X_5459_ _5459_/X _5459_/A VPWR VGND sg13g2_buf_1
XFILLER_59_48 VPWR VGND sg13g2_fill_1
XFILLER_59_37 VPWR VGND sg13g2_decap_8
Xfanout232 _4424_/S _4425_/S VPWR VGND sg13g2_buf_1
Xfanout243 _4350_/S _4359_/S VPWR VGND sg13g2_buf_1
Xfanout254 _4276_/B _4280_/B VPWR VGND sg13g2_buf_1
Xfanout265 _4514_/S _4516_/S VPWR VGND sg13g2_buf_1
Xfanout276 _4203_/A _4431_/B1 VPWR VGND sg13g2_buf_1
Xfanout287 _3233_/B _4211_/B2 VPWR VGND sg13g2_buf_1
Xfanout298 _4839_/A _4701_/A1 VPWR VGND sg13g2_buf_1
XFILLER_59_466 VPWR VGND sg13g2_decap_8
XFILLER_15_503 VPWR VGND sg13g2_decap_8
XFILLER_15_514 VPWR VGND sg13g2_fill_2
XFILLER_15_569 VPWR VGND sg13g2_decap_8
XFILLER_24_84 VPWR VGND sg13g2_fill_1
XFILLER_69_208 VPWR VGND sg13g2_fill_1
XFILLER_2_473 VPWR VGND sg13g2_decap_8
XFILLER_1_11 VPWR VGND sg13g2_fill_1
XFILLER_65_414 VPWR VGND sg13g2_decap_8
XFILLER_38_639 VPWR VGND sg13g2_decap_4
XFILLER_77_296 VPWR VGND sg13g2_decap_8
XFILLER_77_285 VPWR VGND sg13g2_decap_8
XFILLER_37_149 VPWR VGND sg13g2_decap_8
XFILLER_52_119 VPWR VGND sg13g2_fill_1
XFILLER_33_344 VPWR VGND sg13g2_decap_8
XFILLER_33_355 VPWR VGND sg13g2_fill_2
X_4830_ _4848_/C _4840_/A _4831_/B VPWR VGND sg13g2_nand2_1
XFILLER_61_642 VPWR VGND sg13g2_fill_1
XFILLER_33_366 VPWR VGND sg13g2_decap_4
XFILLER_60_152 VPWR VGND sg13g2_decap_8
X_4761_ _4765_/B _4761_/A _4761_/B VPWR VGND sg13g2_xnor2_1
X_4692_ _5200_/D _4691_/A _4690_/Y _4691_/Y VPWR VGND sg13g2_a21oi_1
X_3712_ _3712_/Y _3713_/C _3709_/Y _3711_/Y VPWR VGND sg13g2_o21ai_1
X_3643_ _4445_/B _3895_/A VPWR VGND sg13g2_inv_1
X_5313_ _5313_/Q clkload7/A _5313_/D _5053_/Y VPWR VGND sg13g2_dfrbpq_1
X_3574_ _4016_/B _3574_/A _3574_/B _4030_/A VPWR VGND sg13g2_nand3_1
XFILLER_53_0 VPWR VGND sg13g2_decap_8
X_5244_ _5244_/Q _5392_/CLK _5244_/D _4984_/Y VPWR VGND sg13g2_dfrbpq_1
X_5175_ _5175_/Y _5175_/A VPWR VGND sg13g2_inv_1
XFILLER_28_105 VPWR VGND sg13g2_decap_8
X_4126_ _4126_/Y _4176_/A1 _4474_/B _4125_/Y VPWR VGND sg13g2_o21ai_1
XFILLER_45_28 VPWR VGND sg13g2_fill_2
X_4057_ _4057_/Y _4105_/A1 _4477_/C _4056_/Y VPWR VGND sg13g2_o21ai_1
XFILLER_24_311 VPWR VGND sg13g2_decap_4
XFILLER_36_160 VPWR VGND sg13g2_decap_8
X_3008_ _3008_/Y _4185_/A _4185_/B VPWR VGND sg13g2_nor2_1
XFILLER_24_344 VPWR VGND sg13g2_decap_8
XFILLER_24_388 VPWR VGND sg13g2_decap_8
XFILLER_51_152 VPWR VGND sg13g2_fill_1
X_4959_ _4959_/Y _4959_/A VPWR VGND sg13g2_inv_1
XFILLER_3_248 VPWR VGND sg13g2_decap_8
XFILLER_79_506 VPWR VGND sg13g2_decap_8
XFILLER_59_230 VPWR VGND sg13g2_decap_8
XFILLER_19_116 VPWR VGND sg13g2_decap_4
XFILLER_19_62 VPWR VGND sg13g2_decap_8
XFILLER_74_233 VPWR VGND sg13g2_decap_8
XFILLER_34_108 VPWR VGND sg13g2_decap_8
XFILLER_15_344 VPWR VGND sg13g2_decap_8
XFILLER_27_193 VPWR VGND sg13g2_decap_8
XFILLER_42_130 VPWR VGND sg13g2_decap_4
XFILLER_43_642 VPWR VGND sg13g2_decap_4
XFILLER_15_355 VPWR VGND sg13g2_fill_1
XFILLER_15_366 VPWR VGND sg13g2_decap_8
XFILLER_35_72 VPWR VGND sg13g2_decap_8
XFILLER_51_82 VPWR VGND sg13g2_decap_8
XFILLER_7_521 VPWR VGND sg13g2_decap_4
XFILLER_51_93 VPWR VGND sg13g2_fill_1
XFILLER_7_587 VPWR VGND sg13g2_decap_8
X_3290_ _3302_/A _4111_/A _3290_/B VPWR VGND sg13g2_or2_1
XFILLER_38_436 VPWR VGND sg13g2_decap_8
XFILLER_65_211 VPWR VGND sg13g2_decap_8
XFILLER_76_90 VPWR VGND sg13g2_fill_2
XFILLER_65_266 VPWR VGND sg13g2_decap_4
XFILLER_53_406 VPWR VGND sg13g2_decap_8
XFILLER_53_417 VPWR VGND sg13g2_fill_2
XFILLER_46_491 VPWR VGND sg13g2_decap_8
X_4813_ _4813_/X _4845_/A _4813_/B VPWR VGND sg13g2_xor2_1
XFILLER_61_483 VPWR VGND sg13g2_decap_8
X_4744_ _4744_/Y _4753_/B _4744_/B VPWR VGND sg13g2_xnor2_1
Xrebuffer607 _5440_/A _4568_/C VPWR VGND sg13g2_buf_1
X_4675_ _4676_/B _4678_/B VPWR VGND sg13g2_inv_1
X_3626_ _3636_/A _3626_/A _3626_/B _3626_/C VPWR VGND sg13g2_nand3_1
X_3557_ _3557_/Y _5247_/Q _2714_/A _3692_/A2 VPWR VGND sg13g2_a21oi_1
XFILLER_0_229 VPWR VGND sg13g2_decap_8
X_5227_ _5227_/Q clkload0/A _5227_/D _4967_/Y VPWR VGND sg13g2_dfrbpq_1
X_3488_ _3958_/A _4048_/B _4030_/A VPWR VGND sg13g2_nand2_1
XFILLER_76_509 VPWR VGND sg13g2_decap_8
XFILLER_69_572 VPWR VGND sg13g2_decap_8
XFILLER_29_414 VPWR VGND sg13g2_decap_8
X_5158_ _5158_/Y _5158_/A VPWR VGND sg13g2_inv_1
XFILLER_56_27 VPWR VGND sg13g2_decap_8
XFILLER_29_458 VPWR VGND sg13g2_decap_8
X_5089_ _5089_/Y _5152_/A VPWR VGND sg13g2_inv_1
X_4109_ _4111_/B _4110_/B _4133_/B _4112_/A VPWR VGND sg13g2_a21oi_1
XFILLER_56_255 VPWR VGND sg13g2_fill_1
XFILLER_12_303 VPWR VGND sg13g2_fill_1
XFILLER_40_612 VPWR VGND sg13g2_decap_4
XFILLER_52_450 VPWR VGND sg13g2_decap_8
XFILLER_72_37 VPWR VGND sg13g2_fill_2
XFILLER_24_196 VPWR VGND sg13g2_decap_4
XFILLER_12_369 VPWR VGND sg13g2_decap_8
XFILLER_4_513 VPWR VGND sg13g2_decap_8
XFILLER_4_557 VPWR VGND sg13g2_decap_4
XFILLER_79_325 VPWR VGND sg13g2_fill_1
XFILLER_47_222 VPWR VGND sg13g2_decap_8
XFILLER_75_542 VPWR VGND sg13g2_decap_4
XFILLER_46_82 VPWR VGND sg13g2_fill_1
XFILLER_46_93 VPWR VGND sg13g2_decap_8
XFILLER_30_166 VPWR VGND sg13g2_decap_4
X_2790_ _2790_/Y _5430_/Q _2841_/B _3369_/B1 _5398_/Q _2789_/Y VPWR VGND sg13g2_a221oi_1
XFILLER_11_380 VPWR VGND sg13g2_fill_2
X_4460_ _4460_/Y _3337_/Y _4460_/B VPWR VGND sg13g2_nand2b_1
X_4391_ _5265_/D _4278_/A hold789/X _4393_/S VPWR VGND sg13g2_mux2_1
X_3411_ _3421_/A _3411_/A _3411_/B _3411_/C VPWR VGND sg13g2_nor3_1
X_3342_ _3746_/A _4463_/A _3342_/B VPWR VGND sg13g2_or2_1
XFILLER_3_590 VPWR VGND sg13g2_decap_8
X_3273_ _3274_/B _4440_/B _2974_/C _2986_/A VPWR VGND sg13g2_a21oi_1
XFILLER_38_200 VPWR VGND sg13g2_decap_8
X_5012_ _5012_/Y _5076_/A VPWR VGND sg13g2_inv_1
XFILLER_16_0 VPWR VGND sg13g2_decap_8
XFILLER_26_406 VPWR VGND sg13g2_fill_1
XFILLER_26_417 VPWR VGND sg13g2_decap_8
XFILLER_19_480 VPWR VGND sg13g2_fill_2
XFILLER_34_494 VPWR VGND sg13g2_decap_8
X_2988_ _3238_/A _3253_/B _2992_/C VPWR VGND sg13g2_and2_1
X_4727_ _5204_/D _4745_/S _4726_/X _4722_/Y VPWR VGND sg13g2_a21oi_1
X_4658_ _4660_/B _4667_/B _4658_/B VPWR VGND sg13g2_nand2_1
Xinput90 _2583_/A io_rdata[3] VPWR VGND sg13g2_buf_1
Xhold830 hold830/X _5191_/Q VPWR VGND sg13g2_dlygate4sd3_1
X_3609_ _3611_/C _5319_/Q _3674_/A2 _3689_/B1 _5415_/Q VPWR VGND sg13g2_a22oi_1
XFILLER_1_505 VPWR VGND sg13g2_fill_1
Xhold863 hold863/X _4678_/B VPWR VGND sg13g2_dlygate4sd3_1
Xhold852 hold852/X _4820_/B VPWR VGND sg13g2_dlygate4sd3_1
Xhold841 hold841/X _5399_/Q VPWR VGND sg13g2_dlygate4sd3_1
X_4589_ _4594_/B _5453_/A _4590_/B VPWR VGND sg13g2_nor2b_1
Xhold885 _4691_/B _4688_/B VPWR VGND sg13g2_dlygate4sd3_1
Xhold874 _4748_/B _4749_/C VPWR VGND sg13g2_dlygate4sd3_1
XFILLER_67_37 VPWR VGND sg13g2_decap_8
XFILLER_57_531 VPWR VGND sg13g2_decap_8
XFILLER_72_512 VPWR VGND sg13g2_decap_8
XFILLER_72_556 VPWR VGND sg13g2_decap_8
XFILLER_25_450 VPWR VGND sg13g2_decap_8
XFILLER_32_409 VPWR VGND sg13g2_fill_2
XFILLER_72_589 VPWR VGND sg13g2_decap_8
XFILLER_25_494 VPWR VGND sg13g2_decap_4
XFILLER_32_40 VPWR VGND sg13g2_decap_8
XFILLER_9_638 VPWR VGND sg13g2_decap_8
XFILLER_40_497 VPWR VGND sg13g2_decap_8
XFILLER_8_159 VPWR VGND sg13g2_decap_8
XFILLER_67_317 VPWR VGND sg13g2_decap_8
XFILLER_63_556 VPWR VGND sg13g2_fill_1
XFILLER_16_450 VPWR VGND sg13g2_decap_8
X_3960_ _3962_/B _3961_/B _3992_/B _3961_/A VPWR VGND sg13g2_a21o_1
X_2911_ _2912_/C _3184_/B _3161_/A _3201_/A _3044_/D VPWR VGND sg13g2_or4_1
XFILLER_43_291 VPWR VGND sg13g2_decap_4
X_3891_ _5418_/D hold655/X _3890_/Y _4013_/S VPWR VGND sg13g2_mux2_1
X_2842_ _2842_/Y _5297_/Q _3534_/A2 _3369_/B1 _5393_/Q _2841_/X VPWR VGND sg13g2_a221oi_1
XFILLER_31_497 VPWR VGND sg13g2_decap_8
X_2773_ _2776_/B _5429_/Q _2841_/B _3371_/A2 _5269_/Q VPWR VGND sg13g2_a22oi_1
X_4512_ _5182_/D hold813/X _4085_/Y _4514_/S VPWR VGND sg13g2_mux2_1
XFILLER_7_170 VPWR VGND sg13g2_decap_8
X_4443_ _4443_/Y _4434_/Y _4438_/X _4442_/Y VPWR VGND sg13g2_a21oi_1
X_4374_ _5281_/D _4253_/A hold739/X _4375_/S VPWR VGND sg13g2_mux2_1
X_3325_ _3326_/D _5358_/Q _3668_/A2 _3668_/B1 _5294_/Q VPWR VGND sg13g2_a22oi_1
X_3256_ _3261_/A _4210_/A1 _2834_/Y _3255_/Y VPWR VGND sg13g2_o21ai_1
XFILLER_39_575 VPWR VGND sg13g2_decap_4
X_3187_ _3190_/C _3187_/A _3187_/B VPWR VGND sg13g2_and2_1
XFILLER_66_372 VPWR VGND sg13g2_decap_8
XFILLER_39_597 VPWR VGND sg13g2_decap_8
XFILLER_54_556 VPWR VGND sg13g2_decap_8
XFILLER_34_291 VPWR VGND sg13g2_decap_8
Xhold660 hold660/X _5186_/Q VPWR VGND sg13g2_dlygate4sd3_1
Xhold671 hold671/X _5415_/Q VPWR VGND sg13g2_dlygate4sd3_1
XFILLER_78_25 VPWR VGND sg13g2_fill_1
XFILLER_1_357 VPWR VGND sg13g2_fill_2
Xhold682 hold682/X _5241_/Q VPWR VGND sg13g2_dlygate4sd3_1
Xhold693 hold693/X _5236_/Q VPWR VGND sg13g2_dlygate4sd3_1
XFILLER_76_147 VPWR VGND sg13g2_fill_1
XFILLER_76_136 VPWR VGND sg13g2_decap_8
XFILLER_17_236 VPWR VGND sg13g2_decap_8
XFILLER_57_394 VPWR VGND sg13g2_fill_2
XFILLER_45_567 VPWR VGND sg13g2_fill_2
XFILLER_60_504 VPWR VGND sg13g2_decap_8
XFILLER_5_641 VPWR VGND sg13g2_decap_8
Xoutput209 io_wdata[20] _5456_/X VPWR VGND sg13g2_buf_1
X_3110_ _3110_/Y _2590_/Y _4217_/A1 _3197_/A2 VPWR VGND sg13g2_a21oi_1
XFILLER_68_637 VPWR VGND sg13g2_decap_8
XFILLER_67_103 VPWR VGND sg13g2_decap_4
X_4090_ _4103_/B _3714_/B _4077_/Y _4089_/Y VPWR VGND sg13g2_o21ai_1
XFILLER_68_91 VPWR VGND sg13g2_decap_8
XFILLER_67_158 VPWR VGND sg13g2_decap_8
XFILLER_48_350 VPWR VGND sg13g2_decap_8
X_3041_ _3041_/Y _3161_/A _3157_/B _2796_/Y VPWR VGND sg13g2_a21oi_1
XFILLER_48_383 VPWR VGND sg13g2_decap_8
XFILLER_75_191 VPWR VGND sg13g2_fill_1
X_4992_ _4992_/Y _5160_/A VPWR VGND sg13g2_inv_1
X_3943_ _3943_/Y _4462_/A _3935_/Y _3942_/Y _4043_/A _3941_/Y VPWR VGND sg13g2_a221oi_1
X_3874_ _3876_/B _3874_/A _3874_/B VPWR VGND sg13g2_or2_1
X_2825_ _4440_/A _2825_/A _2825_/B VPWR VGND sg13g2_nand2_1
X_2756_ _4569_/B _2753_/Y _2751_/Y _2755_/Y VPWR VGND sg13g2_a21oi_2
X_2687_ _2688_/B _4360_/A _4394_/B VPWR VGND sg13g2_nand2_1
X_4426_ _5232_/D _4280_/A hold761/X _4427_/B VPWR VGND sg13g2_mux2_1
Xfanout403 _4543_/A _4641_/A VPWR VGND sg13g2_buf_1
Xfanout414 _4045_/A _2671_/Y VPWR VGND sg13g2_buf_1
Xfanout425 _3209_/A1 _2649_/Y VPWR VGND sg13g2_buf_1
Xfanout436 _3556_/B1 _2724_/Y VPWR VGND sg13g2_buf_1
Xfanout447 _3689_/A2 _3534_/A2 VPWR VGND sg13g2_buf_1
X_4357_ _5297_/D _4278_/A hold687/X _4357_/S VPWR VGND sg13g2_mux2_1
Xfanout458 _3583_/B1 _2705_/Y VPWR VGND sg13g2_buf_1
Xfanout469 _3683_/A2 _3548_/A2 VPWR VGND sg13g2_buf_1
X_4288_ _5355_/D _3860_/Y hold740/X _4294_/S VPWR VGND sg13g2_mux2_1
X_3308_ _3308_/Y _4447_/A1 _4095_/A _3313_/A VPWR VGND sg13g2_o21ai_1
XFILLER_58_125 VPWR VGND sg13g2_fill_1
XFILLER_39_361 VPWR VGND sg13g2_decap_8
X_3239_ _3239_/Y _3239_/A _3239_/B VPWR VGND sg13g2_nor2_1
XFILLER_54_386 VPWR VGND sg13g2_decap_8
XFILLER_54_375 VPWR VGND sg13g2_fill_2
XFILLER_22_294 VPWR VGND sg13g2_decap_8
XFILLER_10_456 VPWR VGND sg13g2_decap_8
XFILLER_6_405 VPWR VGND sg13g2_decap_8
XFILLER_49_103 VPWR VGND sg13g2_decap_8
XFILLER_18_501 VPWR VGND sg13g2_fill_1
XFILLER_64_139 VPWR VGND sg13g2_fill_2
XFILLER_64_128 VPWR VGND sg13g2_decap_8
XFILLER_73_640 VPWR VGND sg13g2_decap_8
XFILLER_57_191 VPWR VGND sg13g2_fill_1
XFILLER_72_161 VPWR VGND sg13g2_decap_8
XFILLER_60_301 VPWR VGND sg13g2_decap_8
XFILLER_60_389 VPWR VGND sg13g2_decap_8
Xclkload13 clkload13/Y _5432_/CLK VPWR VGND sg13g2_inv_2
X_3590_ _3590_/X _5188_/Q _3644_/B VPWR VGND sg13g2_and2_1
X_2610_ _2610_/Y _2610_/A VPWR VGND sg13g2_inv_1
X_2541_ _2750_/A _2541_/A VPWR VGND sg13g2_inv_1
XFILLER_55_4 VPWR VGND sg13g2_fill_2
X_5260_ _5260_/Q clkload5/A _5260_/D _5000_/Y VPWR VGND sg13g2_dfrbpq_1
XFILLER_5_471 VPWR VGND sg13g2_decap_8
X_4211_ _4211_/Y _4441_/B _4211_/A2 _3748_/B _4211_/B2 VPWR VGND sg13g2_a22oi_1
X_5191_ _5191_/Q _5421_/CLK _5191_/D _4931_/Y VPWR VGND sg13g2_dfrbpq_1
XFILLER_68_401 VPWR VGND sg13g2_fill_1
X_4142_ _4142_/Y _3254_/A _4135_/Y _4141_/Y VPWR VGND sg13g2_o21ai_1
XFILLER_68_445 VPWR VGND sg13g2_decap_8
X_4073_ _4073_/Y _3239_/A _4067_/Y _4072_/Y VPWR VGND sg13g2_o21ai_1
XFILLER_55_106 VPWR VGND sg13g2_decap_8
X_3024_ _3411_/B _3131_/A _3115_/A _3022_/Y VPWR VGND sg13g2_a21oi_1
XFILLER_36_364 VPWR VGND sg13g2_fill_2
XFILLER_36_375 VPWR VGND sg13g2_decap_8
XFILLER_51_312 VPWR VGND sg13g2_decap_8
XFILLER_63_150 VPWR VGND sg13g2_decap_8
X_4975_ _4975_/Y _5166_/A VPWR VGND sg13g2_inv_1
X_3926_ _3927_/D _4447_/A1 _3921_/B _3920_/Y _4043_/A _3921_/Y VPWR VGND sg13g2_a221oi_1
Xclkload7 clkload7/Y clkload7/A VPWR VGND sg13g2_inv_2
X_3857_ _4478_/A _3857_/A _3854_/Y VPWR VGND sg13g2_nor2b_1
X_3788_ _3788_/Y _5229_/Q _4001_/B2 _4069_/B2 _4444_/A VPWR VGND sg13g2_a22oi_1
X_2808_ _2811_/A _5300_/Q _2879_/A2 _3371_/A2 _5268_/Q VPWR VGND sg13g2_a22oi_1
X_2739_ _2741_/A _5274_/Q _3371_/A2 _3371_/B1 _5338_/Q VPWR VGND sg13g2_a22oi_1
XFILLER_59_16 VPWR VGND sg13g2_decap_8
X_5458_ _5458_/X _5458_/A VPWR VGND sg13g2_buf_1
X_5389_ _5389_/Q _5421_/CLK _5389_/D _5129_/Y VPWR VGND sg13g2_dfrbpq_1
X_4409_ _5248_/D _4255_/A hold709/X _4409_/S VPWR VGND sg13g2_mux2_1
Xfanout233 _4427_/B _4425_/S VPWR VGND sg13g2_buf_1
Xfanout244 _4359_/S _4357_/S VPWR VGND sg13g2_buf_1
Xfanout255 _4280_/B _4282_/B VPWR VGND sg13g2_buf_1
XFILLER_47_618 VPWR VGND sg13g2_decap_8
Xfanout266 _4517_/S _4518_/S VPWR VGND sg13g2_buf_1
Xfanout277 _4431_/B1 _2968_/Y VPWR VGND sg13g2_buf_1
Xfanout288 _4211_/B2 _3009_/Y VPWR VGND sg13g2_buf_1
Xfanout299 _4701_/A1 _4491_/Y VPWR VGND sg13g2_buf_1
XFILLER_75_37 VPWR VGND sg13g2_fill_2
XFILLER_46_139 VPWR VGND sg13g2_decap_8
XFILLER_55_651 VPWR VGND sg13g2_fill_1
XFILLER_27_386 VPWR VGND sg13g2_decap_8
XFILLER_54_172 VPWR VGND sg13g2_decap_4
XFILLER_15_548 VPWR VGND sg13g2_decap_8
XFILLER_42_345 VPWR VGND sg13g2_fill_2
XFILLER_24_30 VPWR VGND sg13g2_decap_4
XFILLER_23_570 VPWR VGND sg13g2_fill_1
XFILLER_10_286 VPWR VGND sg13g2_decap_4
XFILLER_2_452 VPWR VGND sg13g2_fill_1
XFILLER_49_82 VPWR VGND sg13g2_decap_8
XFILLER_1_23 VPWR VGND sg13g2_decap_8
XFILLER_1_56 VPWR VGND sg13g2_decap_4
XFILLER_37_128 VPWR VGND sg13g2_decap_8
XFILLER_1_67 VPWR VGND sg13g2_fill_2
XFILLER_46_651 VPWR VGND sg13g2_fill_1
XFILLER_18_364 VPWR VGND sg13g2_fill_1
XFILLER_65_81 VPWR VGND sg13g2_decap_4
XFILLER_21_518 VPWR VGND sg13g2_decap_8
XFILLER_21_529 VPWR VGND sg13g2_fill_1
XFILLER_33_389 VPWR VGND sg13g2_decap_8
X_4760_ _4787_/D _4761_/A _4761_/B VPWR VGND sg13g2_nor2_1
XFILLER_81_80 VPWR VGND sg13g2_decap_8
X_4691_ _4691_/Y _4691_/A _4691_/B VPWR VGND sg13g2_nor2_1
X_3711_ _3711_/Y _3711_/A _3711_/B VPWR VGND sg13g2_nor2_1
X_3642_ _3642_/Y _3639_/Y _3640_/Y _3641_/Y VPWR VGND sg13g2_a21oi_1
X_5312_ _5312_/Q clkload8/A _5312_/D _5052_/Y VPWR VGND sg13g2_dfrbpq_1
X_3573_ _3573_/X _3507_/A _3506_/B _3572_/Y VPWR VGND sg13g2_a21o_1
XFILLER_46_0 VPWR VGND sg13g2_fill_2
X_5243_ _5243_/Q _5430_/CLK _5243_/D _4983_/Y VPWR VGND sg13g2_dfrbpq_1
X_5174_ _5174_/Y _5174_/A VPWR VGND sg13g2_inv_1
XFILLER_68_220 VPWR VGND sg13g2_decap_8
XFILLER_29_629 VPWR VGND sg13g2_fill_1
X_4125_ _4125_/Y _2601_/Y _4176_/A1 _4177_/A2 VPWR VGND sg13g2_a21oi_1
XFILLER_56_404 VPWR VGND sg13g2_fill_1
X_4056_ _4056_/Y _2606_/Y _2685_/B _4177_/A2 VPWR VGND sg13g2_a21oi_1
X_3007_ _3007_/Y _3007_/A _3007_/B _3007_/C _3007_/D VPWR VGND sg13g2_nand4_1
XFILLER_64_481 VPWR VGND sg13g2_decap_8
XFILLER_12_529 VPWR VGND sg13g2_fill_1
X_4958_ _4958_/Y _4959_/A VPWR VGND sg13g2_inv_1
X_4889_ _4905_/A _4904_/A _4889_/B VPWR VGND sg13g2_xnor2_1
X_3909_ _5417_/D hold752/X _3908_/X _4013_/S VPWR VGND sg13g2_mux2_1
XFILLER_19_41 VPWR VGND sg13g2_decap_8
XFILLER_47_426 VPWR VGND sg13g2_decap_4
XFILLER_15_301 VPWR VGND sg13g2_decap_8
XFILLER_62_407 VPWR VGND sg13g2_decap_8
XFILLER_15_323 VPWR VGND sg13g2_decap_8
XFILLER_27_172 VPWR VGND sg13g2_decap_8
XFILLER_35_51 VPWR VGND sg13g2_decap_8
XFILLER_43_621 VPWR VGND sg13g2_decap_8
XFILLER_30_326 VPWR VGND sg13g2_decap_8
XFILLER_11_551 VPWR VGND sg13g2_decap_4
XFILLER_11_595 VPWR VGND sg13g2_decap_4
XFILLER_7_544 VPWR VGND sg13g2_decap_8
XFILLER_78_573 VPWR VGND sg13g2_decap_8
XFILLER_78_540 VPWR VGND sg13g2_decap_4
XFILLER_38_415 VPWR VGND sg13g2_decap_8
XFILLER_65_245 VPWR VGND sg13g2_fill_2
XFILLER_34_610 VPWR VGND sg13g2_decap_4
XFILLER_46_470 VPWR VGND sg13g2_decap_8
XFILLER_21_337 VPWR VGND sg13g2_decap_4
XFILLER_33_197 VPWR VGND sg13g2_decap_8
X_4812_ _4823_/B _4845_/A _4813_/B VPWR VGND sg13g2_nand2b_1
X_4743_ _4744_/B _4737_/A _4753_/A _4735_/Y VPWR VGND sg13g2_o21ai_1
Xrebuffer608 _3413_/B fanout381/A VPWR VGND sg13g2_buf_1
X_4674_ _4678_/B _4674_/A _4693_/D VPWR VGND sg13g2_xnor2_1
X_3625_ _4446_/C _3626_/A _3626_/B _3626_/C VPWR VGND sg13g2_and3_1
X_3556_ _3556_/Y _5279_/Q _3556_/A2 _3556_/B1 _5343_/Q _3553_/X VPWR VGND sg13g2_a221oi_1
XFILLER_0_208 VPWR VGND sg13g2_decap_8
X_5226_ _5226_/Q _5432_/CLK _5226_/D _4966_/Y VPWR VGND sg13g2_dfrbpq_1
X_3487_ _4030_/A _4019_/B _4019_/C VPWR VGND sg13g2_xnor2_1
XFILLER_69_551 VPWR VGND sg13g2_decap_8
XFILLER_29_437 VPWR VGND sg13g2_decap_8
X_5157_ _5157_/Y _5160_/A VPWR VGND sg13g2_inv_1
X_5088_ _5088_/Y _5152_/A VPWR VGND sg13g2_inv_1
X_4108_ _5409_/D hold741/X _4253_/A _4224_/B VPWR VGND sg13g2_mux2_1
XFILLER_56_223 VPWR VGND sg13g2_decap_8
XFILLER_16_109 VPWR VGND sg13g2_fill_1
X_4039_ _4054_/A _4048_/B _3957_/X _4038_/Y VPWR VGND sg13g2_o21ai_1
XFILLER_71_215 VPWR VGND sg13g2_decap_8
XFILLER_24_120 VPWR VGND sg13g2_decap_4
XFILLER_72_16 VPWR VGND sg13g2_fill_2
XFILLER_72_27 VPWR VGND sg13g2_fill_1
XFILLER_52_484 VPWR VGND sg13g2_fill_2
XFILLER_12_348 VPWR VGND sg13g2_fill_2
XFILLER_20_370 VPWR VGND sg13g2_decap_8
XFILLER_21_97 VPWR VGND sg13g2_fill_2
XFILLER_75_521 VPWR VGND sg13g2_fill_2
XFILLER_62_215 VPWR VGND sg13g2_fill_1
XFILLER_15_120 VPWR VGND sg13g2_fill_2
XFILLER_43_451 VPWR VGND sg13g2_decap_4
XFILLER_62_259 VPWR VGND sg13g2_decap_8
XFILLER_15_197 VPWR VGND sg13g2_decap_8
XFILLER_11_392 VPWR VGND sg13g2_fill_2
XFILLER_7_66 VPWR VGND sg13g2_decap_8
X_4390_ _5266_/D _4355_/A hold755/X _4393_/S VPWR VGND sg13g2_mux2_1
X_3410_ _4130_/A _3046_/A _3046_/B _3409_/Y VPWR VGND sg13g2_o21ai_1
X_3341_ _3342_/B _4444_/A _3341_/B VPWR VGND sg13g2_nor2_1
X_3272_ _3278_/S _3253_/B _3272_/B VPWR VGND sg13g2_nand2b_1
X_5011_ _5011_/Y _5172_/A VPWR VGND sg13g2_inv_1
XFILLER_38_223 VPWR VGND sg13g2_fill_1
XFILLER_38_234 VPWR VGND sg13g2_decap_8
XFILLER_38_256 VPWR VGND sg13g2_decap_8
XFILLER_38_278 VPWR VGND sg13g2_decap_8
XFILLER_66_587 VPWR VGND sg13g2_decap_8
XFILLER_66_565 VPWR VGND sg13g2_decap_4
XFILLER_53_248 VPWR VGND sg13g2_fill_2
XFILLER_53_215 VPWR VGND sg13g2_fill_2
XFILLER_34_451 VPWR VGND sg13g2_decap_8
XFILLER_22_635 VPWR VGND sg13g2_fill_1
XFILLER_61_292 VPWR VGND sg13g2_decap_8
XFILLER_21_156 VPWR VGND sg13g2_fill_1
X_2987_ _2992_/C _4434_/A _3233_/A VPWR VGND sg13g2_nor2_1
X_4726_ _4726_/X _4728_/B _4726_/B VPWR VGND sg13g2_xor2_1
X_4657_ _4657_/X _4649_/A _5196_/Q _4656_/C VPWR VGND sg13g2_a21o_1
Xinput91 input91/X io_rdata[4] VPWR VGND sg13g2_buf_1
Xinput80 _2613_/A io_rdata[23] VPWR VGND sg13g2_buf_1
Xhold820 hold820/X _5323_/Q VPWR VGND sg13g2_dlygate4sd3_1
X_3608_ _3611_/B _5287_/Q _3674_/B1 _3676_/B1 _5351_/Q VPWR VGND sg13g2_a22oi_1
Xhold864 _4876_/A _5219_/Q VPWR VGND sg13g2_dlygate4sd3_1
Xhold853 _4656_/C _5197_/Q VPWR VGND sg13g2_dlygate4sd3_1
Xhold842 hold842/X _5247_/Q VPWR VGND sg13g2_dlygate4sd3_1
Xhold831 hold831/X _5332_/Q VPWR VGND sg13g2_dlygate4sd3_1
X_4588_ _4588_/Y _4531_/A _4586_/Y _4587_/Y VPWR VGND sg13g2_o21ai_1
XFILLER_1_539 VPWR VGND sg13g2_decap_8
Xhold886 hold886/X _5210_/Q VPWR VGND sg13g2_dlygate4sd3_1
Xhold875 hold875/X _4751_/B VPWR VGND sg13g2_dlygate4sd3_1
X_3539_ _3542_/C _2656_/A _2656_/B _3534_/Y _3536_/Y _3537_/Y VPWR VGND sg13g2_a221oi_1
XFILLER_67_16 VPWR VGND sg13g2_decap_8
XFILLER_29_212 VPWR VGND sg13g2_fill_1
X_5209_ _5209_/Q _5216_/CLK _5209_/D _4949_/Y VPWR VGND sg13g2_dfrbpq_1
XFILLER_76_318 VPWR VGND sg13g2_decap_8
XFILLER_57_510 VPWR VGND sg13g2_decap_8
XFILLER_57_565 VPWR VGND sg13g2_fill_1
XFILLER_57_598 VPWR VGND sg13g2_decap_8
XFILLER_44_248 VPWR VGND sg13g2_fill_1
XFILLER_13_602 VPWR VGND sg13g2_decap_8
XFILLER_12_178 VPWR VGND sg13g2_fill_2
XFILLER_8_127 VPWR VGND sg13g2_decap_8
XFILLER_4_388 VPWR VGND sg13g2_decap_8
XFILLER_79_112 VPWR VGND sg13g2_fill_1
XFILLER_48_565 VPWR VGND sg13g2_decap_8
XFILLER_43_270 VPWR VGND sg13g2_fill_1
X_2910_ _3226_/A _3248_/A _2912_/B _3044_/D VPWR VGND sg13g2_nor3_1
XFILLER_16_495 VPWR VGND sg13g2_decap_8
X_3890_ _3890_/Y _3887_/Y _3888_/Y _3889_/Y VPWR VGND sg13g2_o21ai_1
XFILLER_31_454 VPWR VGND sg13g2_decap_4
X_2841_ _2841_/X _5425_/Q _2841_/B VPWR VGND sg13g2_and2_1
X_2772_ _2776_/A _5301_/Q _2879_/A2 _3371_/B1 _5333_/Q VPWR VGND sg13g2_a22oi_1
X_4511_ _5183_/D hold663/X _4059_/Y _4514_/S VPWR VGND sg13g2_mux2_1
X_4442_ _4442_/Y _4442_/A _4442_/B _4442_/C _4442_/D VPWR VGND sg13g2_nor4_1
X_4373_ _5282_/D _4085_/Y hold795/X _4375_/S VPWR VGND sg13g2_mux2_1
X_3324_ _3326_/C _5194_/Q _3637_/B _3682_/B1 _5422_/Q VPWR VGND sg13g2_a22oi_1
X_3255_ _3255_/Y _2986_/A _4211_/A2 _3233_/B _2824_/X VPWR VGND sg13g2_a22oi_1
X_3186_ _3190_/B _3187_/A _3166_/B _3185_/Y VPWR VGND sg13g2_o21ai_1
XFILLER_54_513 VPWR VGND sg13g2_decap_8
XFILLER_54_535 VPWR VGND sg13g2_decap_8
XFILLER_22_454 VPWR VGND sg13g2_decap_8
XFILLER_10_649 VPWR VGND sg13g2_fill_2
XFILLER_22_498 VPWR VGND sg13g2_fill_1
X_4709_ _5202_/D _4705_/B _4708_/Y _4745_/S VPWR VGND sg13g2_mux2_1
Xhold650 _2553_/A _5362_/Q VPWR VGND sg13g2_dlygate4sd3_1
Xhold661 hold661/X _5374_/Q VPWR VGND sg13g2_dlygate4sd3_1
Xhold672 hold672/X _5385_/Q VPWR VGND sg13g2_dlygate4sd3_1
Xhold683 hold683/X _5245_/Q VPWR VGND sg13g2_dlygate4sd3_1
Xhold694 hold694/X _5411_/Q VPWR VGND sg13g2_dlygate4sd3_1
XFILLER_78_59 VPWR VGND sg13g2_decap_8
XFILLER_45_502 VPWR VGND sg13g2_decap_4
XFILLER_17_215 VPWR VGND sg13g2_decap_8
XFILLER_45_535 VPWR VGND sg13g2_decap_8
XFILLER_72_387 VPWR VGND sg13g2_decap_8
XFILLER_13_421 VPWR VGND sg13g2_fill_2
XFILLER_25_281 VPWR VGND sg13g2_fill_1
XFILLER_9_469 VPWR VGND sg13g2_decap_8
XFILLER_5_620 VPWR VGND sg13g2_decap_8
XFILLER_4_130 VPWR VGND sg13g2_decap_4
XFILLER_4_152 VPWR VGND sg13g2_decap_8
XFILLER_68_70 VPWR VGND sg13g2_decap_8
XFILLER_67_137 VPWR VGND sg13g2_decap_8
X_3040_ _3157_/B _3040_/A _3187_/A VPWR VGND sg13g2_nor2b_1
XFILLER_36_546 VPWR VGND sg13g2_decap_8
XFILLER_51_505 VPWR VGND sg13g2_decap_8
XFILLER_63_343 VPWR VGND sg13g2_decap_8
X_4991_ _4991_/Y _5156_/A VPWR VGND sg13g2_inv_1
XFILLER_63_398 VPWR VGND sg13g2_decap_4
XFILLER_63_365 VPWR VGND sg13g2_fill_2
X_3942_ _3942_/Y _3942_/A _3976_/B VPWR VGND sg13g2_xnor2_1
X_3873_ _3874_/B _4445_/B _3895_/B _3879_/B VPWR VGND sg13g2_a21oi_1
X_2824_ _2824_/X _2825_/A _2825_/B VPWR VGND sg13g2_and2_1
XFILLER_76_0 VPWR VGND sg13g2_decap_8
X_2755_ _2755_/Y _5241_/Q _2714_/A _2880_/B1 VPWR VGND sg13g2_a21oi_1
X_2686_ _4238_/C _4483_/B _4318_/A VPWR VGND sg13g2_nand2b_1
X_4425_ _5233_/D _4278_/A hold669/X _4425_/S VPWR VGND sg13g2_mux2_1
Xfanout404 _4556_/S _4641_/A VPWR VGND sg13g2_buf_1
X_4356_ _5298_/D _2818_/A _4350_/S _4355_/Y VPWR VGND sg13g2_a21oi_1
Xfanout415 _4212_/A1 _2671_/Y VPWR VGND sg13g2_buf_1
Xfanout426 _4623_/C _4531_/A VPWR VGND sg13g2_buf_1
Xfanout437 _3689_/B1 _2722_/Y VPWR VGND sg13g2_buf_1
Xfanout448 _2879_/A2 _3534_/A2 VPWR VGND sg13g2_buf_1
X_3307_ _5424_/D hold646/X _4280_/A _4518_/S VPWR VGND sg13g2_mux2_1
Xfanout459 _3682_/B1 _2703_/X VPWR VGND sg13g2_buf_1
X_4287_ _5356_/D _3840_/Y hold746/X _4294_/S VPWR VGND sg13g2_mux2_1
XFILLER_39_340 VPWR VGND sg13g2_decap_8
X_3238_ _3239_/B _3238_/A _3238_/B VPWR VGND sg13g2_or2_1
XFILLER_27_535 VPWR VGND sg13g2_decap_4
X_3169_ _3169_/Y _3169_/A _3169_/B VPWR VGND sg13g2_nor2_1
XFILLER_66_181 VPWR VGND sg13g2_decap_8
XFILLER_54_321 VPWR VGND sg13g2_decap_8
XFILLER_27_546 VPWR VGND sg13g2_fill_1
XFILLER_27_579 VPWR VGND sg13g2_decap_4
XFILLER_42_505 VPWR VGND sg13g2_fill_2
XFILLER_42_538 VPWR VGND sg13g2_decap_8
XFILLER_22_251 VPWR VGND sg13g2_fill_2
XFILLER_10_435 VPWR VGND sg13g2_decap_8
XFILLER_22_262 VPWR VGND sg13g2_decap_4
XFILLER_13_54 VPWR VGND sg13g2_fill_1
XFILLER_13_87 VPWR VGND sg13g2_decap_4
XFILLER_1_122 VPWR VGND sg13g2_fill_1
XFILLER_77_402 VPWR VGND sg13g2_decap_4
XFILLER_77_457 VPWR VGND sg13g2_decap_8
XFILLER_65_619 VPWR VGND sg13g2_decap_4
XFILLER_45_343 VPWR VGND sg13g2_decap_8
XFILLER_45_376 VPWR VGND sg13g2_decap_8
XFILLER_45_387 VPWR VGND sg13g2_fill_2
XFILLER_60_346 VPWR VGND sg13g2_fill_1
XFILLER_60_335 VPWR VGND sg13g2_decap_8
XFILLER_54_72 VPWR VGND sg13g2_fill_1
XFILLER_9_200 VPWR VGND sg13g2_decap_8
Xclkload14 clkload14/Y _5392_/CLK VPWR VGND sg13g2_inv_8
X_2540_ _3443_/A _5414_/Q VPWR VGND sg13g2_inv_1
XFILLER_5_483 VPWR VGND sg13g2_decap_8
X_4210_ _4213_/C _4210_/A1 _3404_/Y _4209_/Y VPWR VGND sg13g2_o21ai_1
X_5190_ _5190_/Q clkload2/A _5190_/D _4930_/Y VPWR VGND sg13g2_dfrbpq_1
X_4141_ _4141_/Y _3563_/B _4140_/Y _4137_/Y VPWR VGND sg13g2_a21oi_1
XFILLER_68_424 VPWR VGND sg13g2_fill_2
X_4072_ _4072_/Y _4095_/A _4450_/C _3714_/A _3102_/A _4071_/Y VPWR VGND sg13g2_a221oi_1
XFILLER_36_310 VPWR VGND sg13g2_decap_8
X_3023_ _3115_/A _3023_/A _3148_/A VPWR VGND sg13g2_nor2b_1
XFILLER_55_129 VPWR VGND sg13g2_fill_2
XFILLER_36_354 VPWR VGND sg13g2_fill_1
XFILLER_48_192 VPWR VGND sg13g2_fill_2
XFILLER_76_490 VPWR VGND sg13g2_decap_4
XFILLER_51_346 VPWR VGND sg13g2_decap_8
X_4974_ _4974_/Y _5134_/A VPWR VGND sg13g2_inv_1
XFILLER_51_357 VPWR VGND sg13g2_fill_1
X_3925_ _3927_/C _3893_/A _3925_/B _3925_/C VPWR VGND sg13g2_nand3b_1
Xclkload8 clkload8/Y clkload8/A VPWR VGND sg13g2_inv_4
X_3856_ _3857_/A _3856_/A _3856_/B _3856_/C VPWR VGND sg13g2_nor3_1
X_3787_ _3787_/Y _3921_/A _3787_/B VPWR VGND sg13g2_nor2_1
X_2807_ _2811_/B _5236_/Q _2926_/B VPWR VGND sg13g2_nand2_1
X_2738_ _2741_/B _5370_/Q _2927_/A2 _3369_/B1 _5402_/Q VPWR VGND sg13g2_a22oi_1
X_5457_ _5457_/X _5457_/A VPWR VGND sg13g2_buf_1
X_4408_ _5249_/D _4253_/A hold658/X _4409_/S VPWR VGND sg13g2_mux2_1
X_2669_ _2669_/Y _4521_/B _3000_/B _2678_/C VPWR VGND sg13g2_nand3_1
X_5388_ _5388_/Q clkload4/A _5388_/D _5128_/Y VPWR VGND sg13g2_dfrbpq_1
Xfanout234 _4425_/S _4410_/S VPWR VGND sg13g2_buf_1
Xfanout245 _4357_/S _4319_/Y VPWR VGND sg13g2_buf_1
Xfanout256 _4273_/S _4282_/B VPWR VGND sg13g2_buf_1
X_4339_ _5309_/D _2558_/Y _4351_/B _4338_/Y VPWR VGND sg13g2_a21oi_1
Xfanout267 _4518_/S _4516_/S VPWR VGND sg13g2_buf_1
Xfanout278 _4483_/B _2685_/Y VPWR VGND sg13g2_buf_1
Xfanout289 _3721_/A _2730_/Y VPWR VGND sg13g2_buf_1
XFILLER_75_16 VPWR VGND sg13g2_decap_8
XFILLER_46_107 VPWR VGND sg13g2_decap_4
XFILLER_75_49 VPWR VGND sg13g2_decap_4
XFILLER_15_527 VPWR VGND sg13g2_decap_8
XFILLER_42_302 VPWR VGND sg13g2_decap_8
XFILLER_42_379 VPWR VGND sg13g2_decap_8
XFILLER_10_210 VPWR VGND sg13g2_decap_4
XFILLER_23_582 VPWR VGND sg13g2_decap_8
XFILLER_10_243 VPWR VGND sg13g2_fill_1
XFILLER_6_258 VPWR VGND sg13g2_decap_8
XFILLER_6_0 VPWR VGND sg13g2_decap_8
XFILLER_77_232 VPWR VGND sg13g2_fill_2
XFILLER_18_343 VPWR VGND sg13g2_decap_4
XFILLER_1_79 VPWR VGND sg13g2_decap_4
XFILLER_46_630 VPWR VGND sg13g2_decap_8
XFILLER_80_408 VPWR VGND sg13g2_fill_1
XFILLER_18_398 VPWR VGND sg13g2_decap_4
XFILLER_61_633 VPWR VGND sg13g2_fill_1
X_3710_ _3711_/B _3983_/A _3966_/A VPWR VGND sg13g2_nor2_1
XFILLER_60_187 VPWR VGND sg13g2_fill_2
X_4690_ _4690_/Y _4690_/A _4690_/B VPWR VGND sg13g2_xnor2_1
X_3641_ _3641_/Y _5257_/Q _2694_/B _3671_/B1 VPWR VGND sg13g2_a21oi_1
X_3572_ _3572_/Y _4062_/A _3571_/Y _3714_/A VPWR VGND sg13g2_a21oi_1
X_5311_ _5311_/Q _5414_/CLK _5311_/D _5051_/Y VPWR VGND sg13g2_dfrbpq_1
X_5242_ _5242_/Q _5434_/CLK _5242_/D _4982_/Y VPWR VGND sg13g2_dfrbpq_1
X_5173_ _5173_/Y _5173_/A VPWR VGND sg13g2_inv_1
X_4124_ _4474_/B _4112_/Y _4113_/X _4123_/Y VPWR VGND sg13g2_o21ai_1
Xinput1 input1/X dmem_rdata[0] VPWR VGND sg13g2_buf_1
XFILLER_68_287 VPWR VGND sg13g2_decap_8
X_4055_ _4477_/C _4040_/Y _4041_/X _4054_/Y VPWR VGND sg13g2_a21o_1
XFILLER_56_449 VPWR VGND sg13g2_decap_4
X_3006_ _3748_/B _3007_/A _3007_/B _3007_/C _3007_/D VPWR VGND sg13g2_and4_1
XFILLER_51_121 VPWR VGND sg13g2_decap_8
XFILLER_52_644 VPWR VGND sg13g2_decap_4
XFILLER_51_176 VPWR VGND sg13g2_decap_8
X_4957_ _4957_/Y _4959_/A VPWR VGND sg13g2_inv_1
X_4888_ _4890_/B _4871_/B _4885_/X _4887_/Y VPWR VGND sg13g2_o21ai_1
X_3908_ _3908_/X input19/X _3889_/B _3907_/Y VPWR VGND sg13g2_a21o_1
X_3839_ _3839_/Y _3887_/B _4481_/A _3065_/Y VPWR VGND sg13g2_a21oi_1
XFILLER_10_55 VPWR VGND sg13g2_decap_8
XFILLER_10_88 VPWR VGND sg13g2_decap_8
XFILLER_59_287 VPWR VGND sg13g2_fill_2
XFILLER_74_257 VPWR VGND sg13g2_fill_1
XFILLER_30_305 VPWR VGND sg13g2_decap_8
XFILLER_35_96 VPWR VGND sg13g2_decap_8
XFILLER_42_165 VPWR VGND sg13g2_decap_8
XFILLER_30_349 VPWR VGND sg13g2_decap_8
XFILLER_11_574 VPWR VGND sg13g2_decap_8
XFILLER_7_567 VPWR VGND sg13g2_fill_2
XFILLER_18_162 VPWR VGND sg13g2_fill_2
X_4811_ _4813_/B _4846_/A _4846_/B _4848_/A VPWR VGND sg13g2_o21ai_1
XFILLER_33_165 VPWR VGND sg13g2_decap_8
X_4742_ _4753_/B _4742_/A _4742_/B VPWR VGND sg13g2_xnor2_1
Xrebuffer609 fanout381/A _2708_/Y VPWR VGND sg13g2_buf_2
X_4673_ _5198_/D _4691_/A _4672_/Y _4668_/Y VPWR VGND sg13g2_a21oi_1
X_3624_ _3626_/C _3624_/A _3624_/B VPWR VGND sg13g2_and2_1
X_3555_ _3555_/Y _5375_/Q _3687_/B _3555_/B1 _5407_/Q _3554_/Y VPWR VGND sg13g2_a221oi_1
X_3486_ _3708_/B _4019_/B _4019_/C VPWR VGND sg13g2_nor2_1
X_5225_ _5225_/Q _5432_/CLK _5225_/D _4965_/Y VPWR VGND sg13g2_dfrbpq_1
X_5156_ _5156_/Y _5156_/A VPWR VGND sg13g2_inv_1
XFILLER_69_585 VPWR VGND sg13g2_decap_4
XFILLER_56_202 VPWR VGND sg13g2_decap_8
X_5087_ _5087_/Y _5154_/A VPWR VGND sg13g2_inv_1
X_4107_ _4253_/A _2604_/Y _4128_/A2 _4105_/Y _4106_/Y VPWR VGND sg13g2_a22oi_1
X_4038_ _4038_/Y _4048_/B _3957_/X _3856_/A VPWR VGND sg13g2_a21oi_1
XFILLER_52_430 VPWR VGND sg13g2_decap_8
XFILLER_72_39 VPWR VGND sg13g2_fill_1
XFILLER_64_290 VPWR VGND sg13g2_decap_8
XFILLER_52_463 VPWR VGND sg13g2_decap_8
XFILLER_21_21 VPWR VGND sg13g2_decap_8
XFILLER_79_316 VPWR VGND sg13g2_fill_1
Xoutput190 imem_addr[4] _5197_/Q VPWR VGND sg13g2_buf_1
XFILLER_47_202 VPWR VGND sg13g2_decap_4
XFILLER_35_419 VPWR VGND sg13g2_decap_8
XFILLER_47_257 VPWR VGND sg13g2_decap_8
XFILLER_28_493 VPWR VGND sg13g2_fill_2
XFILLER_15_132 VPWR VGND sg13g2_decap_4
XFILLER_15_176 VPWR VGND sg13g2_decap_8
XFILLER_30_157 VPWR VGND sg13g2_decap_4
XFILLER_62_94 VPWR VGND sg13g2_decap_8
XFILLER_11_382 VPWR VGND sg13g2_fill_1
XFILLER_7_375 VPWR VGND sg13g2_decap_8
XFILLER_7_386 VPWR VGND sg13g2_fill_2
X_3340_ _3340_/Y _4463_/A VPWR VGND sg13g2_inv_1
X_5010_ _5010_/Y _5138_/A VPWR VGND sg13g2_inv_1
X_3271_ _3272_/B _4440_/B _3313_/A _2986_/A VPWR VGND sg13g2_o21ai_1
XFILLER_38_246 VPWR VGND sg13g2_decap_4
XFILLER_66_544 VPWR VGND sg13g2_decap_8
XFILLER_46_290 VPWR VGND sg13g2_decap_8
XFILLER_81_569 VPWR VGND sg13g2_decap_8
XFILLER_61_271 VPWR VGND sg13g2_decap_8
X_2986_ _3253_/B _2986_/A _4440_/B _3313_/A VPWR VGND sg13g2_nor3_2
X_4725_ _4726_/B _4725_/A _4725_/B VPWR VGND sg13g2_nand2_1
X_4656_ _4667_/B _5195_/Q _5196_/Q _4656_/C VPWR VGND sg13g2_nand3_1
Xinput81 _2615_/A io_rdata[24] VPWR VGND sg13g2_buf_1
Xinput70 input70/X io_rdata[14] VPWR VGND sg13g2_buf_1
Xhold821 hold821/X _5291_/Q VPWR VGND sg13g2_dlygate4sd3_1
Xhold810 hold810/X _5357_/Q VPWR VGND sg13g2_dlygate4sd3_1
X_4587_ _4587_/Y input40/X _4638_/A _5452_/A _4580_/B VPWR VGND sg13g2_a22oi_1
X_3607_ _3611_/A _5187_/Q _3644_/B VPWR VGND sg13g2_nand2_1
Xinput92 input92/X io_rdata[5] VPWR VGND sg13g2_buf_1
Xhold854 _4658_/B _4657_/X VPWR VGND sg13g2_dlygate4sd3_1
Xhold843 _4649_/A _5195_/Q VPWR VGND sg13g2_dlygate4sd3_1
Xhold832 hold832/X _5432_/Q VPWR VGND sg13g2_dlygate4sd3_1
X_3538_ _5453_/A _3534_/Y _3536_/Y _3537_/Y VPWR VGND sg13g2_a21oi_1
XFILLER_1_518 VPWR VGND sg13g2_decap_8
Xhold887 _4894_/A _5222_/Q VPWR VGND sg13g2_dlygate4sd3_1
Xhold876 _4772_/A _5209_/Q VPWR VGND sg13g2_dlygate4sd3_1
Xhold865 _4838_/A _5216_/Q VPWR VGND sg13g2_dlygate4sd3_1
X_3469_ _3574_/B _3472_/B VPWR VGND sg13g2_inv_1
X_5208_ _5208_/Q _5216_/CLK _5208_/D _4948_/Y VPWR VGND sg13g2_dfrbpq_1
X_5139_ _5139_/Y _5172_/A VPWR VGND sg13g2_inv_1
XFILLER_69_382 VPWR VGND sg13g2_decap_8
XFILLER_57_544 VPWR VGND sg13g2_decap_8
XFILLER_16_21 VPWR VGND sg13g2_decap_4
XFILLER_25_485 VPWR VGND sg13g2_fill_2
XFILLER_40_411 VPWR VGND sg13g2_decap_8
XFILLER_16_98 VPWR VGND sg13g2_decap_8
XFILLER_40_422 VPWR VGND sg13g2_fill_1
XFILLER_52_293 VPWR VGND sg13g2_decap_4
XFILLER_80_591 VPWR VGND sg13g2_decap_4
XFILLER_12_157 VPWR VGND sg13g2_decap_4
XFILLER_4_301 VPWR VGND sg13g2_fill_2
XFILLER_0_584 VPWR VGND sg13g2_decap_8
XFILLER_75_330 VPWR VGND sg13g2_decap_8
XFILLER_75_363 VPWR VGND sg13g2_decap_8
XFILLER_35_238 VPWR VGND sg13g2_decap_8
XFILLER_75_385 VPWR VGND sg13g2_decap_8
XFILLER_16_430 VPWR VGND sg13g2_decap_8
XFILLER_31_411 VPWR VGND sg13g2_decap_8
XFILLER_73_82 VPWR VGND sg13g2_decap_4
XFILLER_31_433 VPWR VGND sg13g2_decap_8
X_2840_ _2840_/Y _2840_/A _2840_/B _2840_/C _2840_/D VPWR VGND sg13g2_nand4_1
XFILLER_73_93 VPWR VGND sg13g2_fill_1
X_2771_ _2771_/Y _4676_/A _3704_/A VPWR VGND sg13g2_nand2_1
X_4510_ _5184_/D hold666/X _4249_/A _4514_/S VPWR VGND sg13g2_mux2_1
X_4441_ _4442_/D _4441_/A _4441_/B _4441_/C _4441_/D VPWR VGND sg13g2_nand4_1
X_4372_ _5283_/D _4059_/Y hold679/X _4375_/S VPWR VGND sg13g2_mux2_1
X_3323_ _3326_/B _5390_/Q _3581_/B VPWR VGND sg13g2_nand2_1
XFILLER_21_0 VPWR VGND sg13g2_decap_8
X_3254_ _3254_/Y _3254_/A _3254_/B VPWR VGND sg13g2_nor2_1
X_3185_ _3185_/Y _3210_/B _3211_/B _3236_/B1 _3166_/A VPWR VGND sg13g2_a22oi_1
XFILLER_66_363 VPWR VGND sg13g2_decap_4
XFILLER_81_300 VPWR VGND sg13g2_fill_1
XFILLER_41_208 VPWR VGND sg13g2_decap_8
XFILLER_22_433 VPWR VGND sg13g2_decap_8
XFILLER_62_591 VPWR VGND sg13g2_fill_2
XFILLER_10_628 VPWR VGND sg13g2_decap_8
X_2969_ _2969_/X _4185_/B _3056_/A VPWR VGND sg13g2_or2_1
X_4708_ _4708_/Y _4730_/B _4708_/B VPWR VGND sg13g2_xnor2_1
XFILLER_5_109 VPWR VGND sg13g2_decap_8
X_4639_ _4642_/S _5466_/A _4639_/B _4639_/C VPWR VGND sg13g2_or3_1
Xhold640 _2544_/A _5380_/Q VPWR VGND sg13g2_dlygate4sd3_1
Xhold651 hold651/X _5423_/Q VPWR VGND sg13g2_dlygate4sd3_1
Xhold662 hold662/X _5408_/Q VPWR VGND sg13g2_dlygate4sd3_1
XFILLER_78_38 VPWR VGND sg13g2_decap_8
XFILLER_1_337 VPWR VGND sg13g2_decap_4
Xhold673 hold673/X _5390_/Q VPWR VGND sg13g2_dlygate4sd3_1
Xhold684 hold684/X _5239_/Q VPWR VGND sg13g2_dlygate4sd3_1
Xhold695 hold695/X _5338_/Q VPWR VGND sg13g2_dlygate4sd3_1
XFILLER_69_190 VPWR VGND sg13g2_fill_1
XFILLER_27_53 VPWR VGND sg13g2_decap_8
XFILLER_60_539 VPWR VGND sg13g2_decap_8
XFILLER_13_488 VPWR VGND sg13g2_fill_1
XFILLER_13_499 VPWR VGND sg13g2_fill_1
XFILLER_4_24 VPWR VGND sg13g2_decap_4
XFILLER_36_514 VPWR VGND sg13g2_decap_8
XFILLER_75_160 VPWR VGND sg13g2_decap_4
XFILLER_75_182 VPWR VGND sg13g2_decap_8
X_4990_ _4990_/Y _5150_/A VPWR VGND sg13g2_inv_1
XFILLER_63_388 VPWR VGND sg13g2_fill_2
XFILLER_16_293 VPWR VGND sg13g2_decap_8
X_3941_ _3941_/Y _3941_/A _3941_/B _3941_/C _3941_/D VPWR VGND sg13g2_nand4_1
X_3872_ _3886_/B _3869_/Y _3871_/Y _3868_/A VPWR VGND sg13g2_o21ai_1
XFILLER_31_263 VPWR VGND sg13g2_decap_4
XFILLER_31_285 VPWR VGND sg13g2_decap_4
X_2823_ _2825_/B _2823_/A _2823_/B _2823_/C _2823_/D VPWR VGND sg13g2_and4_1
XFILLER_31_296 VPWR VGND sg13g2_decap_8
X_2754_ _4629_/B _2754_/A _2754_/B VPWR VGND sg13g2_nor2_1
X_2685_ _2685_/Y _2960_/A _2685_/B _2685_/C VPWR VGND sg13g2_nor3_1
X_4424_ _5234_/D _4355_/A hold717/X _4424_/S VPWR VGND sg13g2_mux2_1
Xfanout405 _4641_/A _2682_/Y VPWR VGND sg13g2_buf_1
X_4355_ _4355_/Y _4355_/A _4359_/S VPWR VGND sg13g2_nor2_1
Xfanout416 _3065_/B _2658_/Y VPWR VGND sg13g2_buf_1
Xfanout427 _4531_/A _4521_/Y VPWR VGND sg13g2_buf_1
Xfanout438 _3555_/B1 _2722_/Y VPWR VGND sg13g2_buf_1
X_3306_ _4280_/A _2580_/Y _4178_/A2 _3304_/Y _3305_/Y VPWR VGND sg13g2_a22oi_1
XFILLER_59_606 VPWR VGND sg13g2_fill_1
Xfanout449 _3534_/A2 _2717_/X VPWR VGND sg13g2_buf_1
X_4286_ _5357_/D _3815_/Y hold810/X _4294_/S VPWR VGND sg13g2_mux2_1
XFILLER_58_116 VPWR VGND sg13g2_fill_2
X_3237_ _3238_/B _3253_/A _3253_/B _3025_/A VPWR VGND sg13g2_a21oi_1
XFILLER_58_149 VPWR VGND sg13g2_fill_2
XFILLER_27_503 VPWR VGND sg13g2_fill_2
X_3168_ _3169_/B _4208_/A _3161_/A _3167_/Y VPWR VGND sg13g2_o21ai_1
XFILLER_73_119 VPWR VGND sg13g2_decap_8
XFILLER_27_558 VPWR VGND sg13g2_decap_8
XFILLER_39_396 VPWR VGND sg13g2_fill_1
X_3099_ _3100_/B _3101_/A _3099_/B VPWR VGND sg13g2_xnor2_1
XFILLER_81_174 VPWR VGND sg13g2_decap_8
XFILLER_54_377 VPWR VGND sg13g2_fill_1
XFILLER_54_366 VPWR VGND sg13g2_fill_2
XFILLER_22_230 VPWR VGND sg13g2_decap_8
XFILLER_13_33 VPWR VGND sg13g2_decap_8
XFILLER_13_66 VPWR VGND sg13g2_decap_8
XFILLER_2_635 VPWR VGND sg13g2_decap_8
XFILLER_8_4 VPWR VGND sg13g2_fill_1
XFILLER_49_149 VPWR VGND sg13g2_fill_2
XFILLER_38_85 VPWR VGND sg13g2_decap_8
XFILLER_57_171 VPWR VGND sg13g2_decap_4
XFILLER_57_160 VPWR VGND sg13g2_fill_2
XFILLER_18_569 VPWR VGND sg13g2_decap_8
XFILLER_45_322 VPWR VGND sg13g2_decap_8
XFILLER_33_528 VPWR VGND sg13g2_decap_8
XFILLER_26_591 VPWR VGND sg13g2_decap_8
XFILLER_60_358 VPWR VGND sg13g2_decap_8
Xclkload15 clkload15/Y _5206_/CLK VPWR VGND sg13g2_inv_4
X_4140_ _4140_/Y _3973_/C _4138_/Y _4139_/Y VPWR VGND sg13g2_o21ai_1
X_4071_ _4071_/Y _4071_/A _4071_/B _4071_/C VPWR VGND sg13g2_nand3_1
X_3022_ _3022_/Y _3022_/A _3022_/B VPWR VGND sg13g2_nor2_1
XFILLER_36_344 VPWR VGND sg13g2_decap_4
XFILLER_17_591 VPWR VGND sg13g2_fill_1
XFILLER_24_539 VPWR VGND sg13g2_decap_8
X_4973_ _4973_/Y _5112_/A VPWR VGND sg13g2_inv_1
X_3924_ _3925_/C _3916_/B _3659_/Y _3856_/A VPWR VGND sg13g2_a21oi_1
XFILLER_32_561 VPWR VGND sg13g2_decap_8
Xclkload9 clkload9/Y clkload9/A VPWR VGND sg13g2_inv_2
X_3855_ _3856_/C _3855_/A _3855_/B VPWR VGND sg13g2_and2_1
X_3786_ _3786_/X _4444_/A _3786_/B VPWR VGND sg13g2_and2_1
X_2806_ _2992_/B _4435_/B VPWR VGND sg13g2_inv_1
X_2737_ _2741_/C _5242_/Q _3677_/B VPWR VGND sg13g2_nand2_1
X_5456_ _5456_/X _5456_/A VPWR VGND sg13g2_buf_1
X_2668_ _2668_/X _4521_/B _3000_/B _2678_/C VPWR VGND sg13g2_and3_1
X_4407_ _5250_/D _4085_/Y hold723/X _4407_/S VPWR VGND sg13g2_mux2_1
X_5387_ _5387_/Q _5421_/CLK _5387_/D _5127_/Y VPWR VGND sg13g2_dfrbpq_1
X_2599_ _2599_/Y _2599_/A VPWR VGND sg13g2_inv_1
Xfanout235 _4371_/S _4375_/S VPWR VGND sg13g2_buf_1
Xfanout246 _4294_/S _4299_/S VPWR VGND sg13g2_buf_1
X_4338_ _4338_/Y _4338_/A _4351_/B VPWR VGND sg13g2_nor2_1
XFILLER_59_425 VPWR VGND sg13g2_decap_8
Xfanout257 _4282_/B _4238_/Y VPWR VGND sg13g2_buf_1
Xfanout268 _4516_/S _2688_/Y VPWR VGND sg13g2_buf_1
Xfanout279 _4208_/B _4201_/C VPWR VGND sg13g2_buf_1
X_4269_ _5367_/D _2550_/Y _4282_/B _4268_/Y VPWR VGND sg13g2_o21ai_1
XFILLER_75_39 VPWR VGND sg13g2_fill_1
XFILLER_74_439 VPWR VGND sg13g2_decap_8
XFILLER_27_333 VPWR VGND sg13g2_fill_2
XFILLER_67_491 VPWR VGND sg13g2_fill_2
XFILLER_27_366 VPWR VGND sg13g2_fill_2
XFILLER_27_377 VPWR VGND sg13g2_decap_4
XFILLER_23_561 VPWR VGND sg13g2_decap_8
XFILLER_50_380 VPWR VGND sg13g2_decap_8
XFILLER_6_226 VPWR VGND sg13g2_fill_2
XFILLER_6_215 VPWR VGND sg13g2_fill_1
XFILLER_40_42 VPWR VGND sg13g2_fill_2
XFILLER_77_211 VPWR VGND sg13g2_decap_8
XFILLER_65_428 VPWR VGND sg13g2_decap_8
XFILLER_18_311 VPWR VGND sg13g2_fill_2
XFILLER_33_303 VPWR VGND sg13g2_decap_4
XFILLER_73_472 VPWR VGND sg13g2_fill_1
XFILLER_60_177 VPWR VGND sg13g2_fill_1
XFILLER_60_166 VPWR VGND sg13g2_fill_1
X_3640_ _3640_/Y _5385_/Q _3581_/B _3668_/A2 _5353_/Q _3638_/X VPWR VGND sg13g2_a221oi_1
X_3571_ _3571_/Y _4113_/B _3570_/B _4087_/A VPWR VGND sg13g2_o21ai_1
XFILLER_60_4 VPWR VGND sg13g2_decap_4
X_5310_ _5310_/Q _5424_/CLK _5310_/D _5050_/Y VPWR VGND sg13g2_dfrbpq_1
X_5241_ _5241_/Q clkload9/A _5241_/D _4981_/Y VPWR VGND sg13g2_dfrbpq_1
X_5172_ _5172_/Y _5172_/A VPWR VGND sg13g2_inv_1
X_4123_ _4123_/Y _4123_/A _4123_/B _4123_/C _4123_/D VPWR VGND sg13g2_nor4_1
XFILLER_68_244 VPWR VGND sg13g2_fill_2
XFILLER_28_119 VPWR VGND sg13g2_fill_1
Xinput2 input2/X dmem_rdata[10] VPWR VGND sg13g2_buf_1
X_4054_ _4054_/Y _4054_/A _4054_/B _4054_/C VPWR VGND sg13g2_nand3_1
XFILLER_56_439 VPWR VGND sg13g2_decap_4
XFILLER_49_491 VPWR VGND sg13g2_decap_8
X_3005_ _3007_/D _5176_/Q _2870_/B _3548_/A2 _5308_/Q VPWR VGND sg13g2_a22oi_1
XFILLER_71_409 VPWR VGND sg13g2_decap_8
XFILLER_52_623 VPWR VGND sg13g2_decap_4
XFILLER_24_358 VPWR VGND sg13g2_decap_8
X_4956_ _4956_/Y _4959_/A VPWR VGND sg13g2_inv_1
XFILLER_20_520 VPWR VGND sg13g2_decap_8
X_4887_ _4887_/Y _4879_/A _4879_/B _4886_/Y VPWR VGND sg13g2_a21oi_1
X_3907_ _3907_/Y _3887_/B _4478_/B _3906_/Y VPWR VGND sg13g2_a21oi_1
X_3838_ _3838_/Y _3838_/A _3838_/B VPWR VGND sg13g2_nand2_1
XFILLER_3_207 VPWR VGND sg13g2_decap_4
X_3769_ _3771_/C _4450_/B _4449_/A VPWR VGND sg13g2_nand2_1
XFILLER_10_67 VPWR VGND sg13g2_decap_8
X_5439_ _5439_/X _5439_/A VPWR VGND sg13g2_buf_1
XFILLER_59_211 VPWR VGND sg13g2_fill_2
XFILLER_59_255 VPWR VGND sg13g2_fill_2
XFILLER_59_244 VPWR VGND sg13g2_fill_1
XFILLER_19_76 VPWR VGND sg13g2_decap_4
XFILLER_28_642 VPWR VGND sg13g2_fill_2
XFILLER_74_247 VPWR VGND sg13g2_decap_4
XFILLER_59_299 VPWR VGND sg13g2_decap_8
XFILLER_43_601 VPWR VGND sg13g2_decap_8
XFILLER_70_420 VPWR VGND sg13g2_decap_8
XFILLER_55_472 VPWR VGND sg13g2_decap_8
XFILLER_70_497 VPWR VGND sg13g2_fill_1
XFILLER_70_486 VPWR VGND sg13g2_decap_8
XFILLER_51_41 VPWR VGND sg13g2_fill_1
XFILLER_7_502 VPWR VGND sg13g2_decap_4
XFILLER_65_247 VPWR VGND sg13g2_fill_1
XFILLER_65_225 VPWR VGND sg13g2_fill_2
XFILLER_18_174 VPWR VGND sg13g2_decap_8
XFILLER_80_217 VPWR VGND sg13g2_fill_2
XFILLER_33_144 VPWR VGND sg13g2_decap_8
X_4810_ _4848_/A _4807_/A _4802_/B _4809_/Y VPWR VGND sg13g2_a21oi_1
XFILLER_61_431 VPWR VGND sg13g2_decap_8
XFILLER_61_497 VPWR VGND sg13g2_decap_8
XFILLER_14_391 VPWR VGND sg13g2_decap_8
X_4741_ _4741_/Y _4742_/B VPWR VGND sg13g2_inv_1
X_4672_ _4672_/Y _4672_/A _4672_/B VPWR VGND sg13g2_xnor2_1
X_3623_ _3624_/B _5354_/Q _3683_/B1 _3682_/B1 _5418_/Q VPWR VGND sg13g2_a22oi_1
XFILLER_51_0 VPWR VGND sg13g2_fill_2
X_3554_ _3554_/Y _2557_/Y _2941_/B _3692_/A2 VPWR VGND sg13g2_o21ai_1
X_3485_ _4019_/C _2716_/A _5457_/A _3634_/A VPWR VGND sg13g2_mux2_1
X_5224_ _5224_/Q _5224_/CLK _5224_/D _4964_/Y VPWR VGND sg13g2_dfrbpq_1
X_5155_ _5155_/Y _5162_/A VPWR VGND sg13g2_inv_1
X_5086_ _5086_/Y _5152_/A VPWR VGND sg13g2_inv_1
X_4106_ _4106_/Y _4360_/A _2666_/C _4128_/A2 VPWR VGND sg13g2_a21oi_1
XFILLER_25_601 VPWR VGND sg13g2_fill_2
X_4037_ _5412_/D hold824/X _4249_/A _4224_/B VPWR VGND sg13g2_mux2_1
XFILLER_56_269 VPWR VGND sg13g2_decap_8
XFILLER_37_483 VPWR VGND sg13g2_decap_4
XFILLER_24_133 VPWR VGND sg13g2_decap_8
XFILLER_72_18 VPWR VGND sg13g2_fill_1
XFILLER_12_317 VPWR VGND sg13g2_fill_1
XFILLER_52_497 VPWR VGND sg13g2_decap_8
X_4939_ _4939_/Y _4942_/A VPWR VGND sg13g2_inv_1
XFILLER_4_527 VPWR VGND sg13g2_decap_4
Xoutput180 imem_addr[24] _5217_/Q VPWR VGND sg13g2_buf_1
Xoutput191 imem_addr[5] _5198_/Q VPWR VGND sg13g2_buf_1
XFILLER_47_236 VPWR VGND sg13g2_decap_8
XFILLER_75_578 VPWR VGND sg13g2_decap_8
XFILLER_75_556 VPWR VGND sg13g2_decap_4
XFILLER_16_612 VPWR VGND sg13g2_decap_8
XFILLER_28_472 VPWR VGND sg13g2_decap_8
XFILLER_43_431 VPWR VGND sg13g2_decap_8
XFILLER_55_280 VPWR VGND sg13g2_decap_8
XFILLER_31_626 VPWR VGND sg13g2_decap_8
XFILLER_70_250 VPWR VGND sg13g2_decap_8
XFILLER_43_497 VPWR VGND sg13g2_fill_1
XFILLER_62_73 VPWR VGND sg13g2_decap_8
XFILLER_7_310 VPWR VGND sg13g2_fill_2
XFILLER_7_24 VPWR VGND sg13g2_fill_2
XFILLER_11_394 VPWR VGND sg13g2_fill_1
XFILLER_7_354 VPWR VGND sg13g2_decap_8
XFILLER_7_343 VPWR VGND sg13g2_decap_4
X_3270_ _3270_/Y _3270_/A _3270_/B VPWR VGND sg13g2_xnor2_1
XFILLER_23_4 VPWR VGND sg13g2_decap_8
XFILLER_38_214 VPWR VGND sg13g2_decap_8
XFILLER_66_523 VPWR VGND sg13g2_decap_8
XFILLER_53_217 VPWR VGND sg13g2_fill_1
XFILLER_19_494 VPWR VGND sg13g2_fill_2
XFILLER_61_250 VPWR VGND sg13g2_fill_1
X_4724_ _4728_/B _4724_/A _4724_/B VPWR VGND sg13g2_xnor2_1
X_2985_ _3060_/B _4159_/A _2985_/B VPWR VGND sg13g2_nor2_1
X_4655_ _4655_/Y _4664_/A _4654_/Y _4650_/Y VPWR VGND sg13g2_a21oi_1
Xinput82 _2617_/A io_rdata[25] VPWR VGND sg13g2_buf_1
Xinput71 _2597_/A io_rdata[15] VPWR VGND sg13g2_buf_1
Xinput60 _4670_/A imem_data[5] VPWR VGND sg13g2_buf_1
Xhold811 hold811/X _5312_/Q VPWR VGND sg13g2_dlygate4sd3_1
Xhold800 hold800/X _5271_/Q VPWR VGND sg13g2_dlygate4sd3_1
X_4586_ _4586_/Y _4590_/B _4585_/Y VPWR VGND sg13g2_nor2b_1
X_3606_ _3942_/A _3606_/A _3606_/B _3606_/C _3606_/D VPWR VGND sg13g2_nand4_1
Xinput93 input93/X io_rdata[6] VPWR VGND sg13g2_buf_1
Xhold855 hold855/X _4660_/B VPWR VGND sg13g2_dlygate4sd3_1
Xhold844 _5195_/D _4648_/Y VPWR VGND sg13g2_dlygate4sd3_1
Xhold833 hold833/X _5400_/Q VPWR VGND sg13g2_dlygate4sd3_1
Xhold822 hold822/X _5375_/Q VPWR VGND sg13g2_dlygate4sd3_1
X_3537_ _3537_/Y _5248_/Q _2754_/A _2754_/B VPWR VGND sg13g2_a21oi_1
Xhold888 hold888/X _5204_/Q VPWR VGND sg13g2_dlygate4sd3_1
Xhold877 _4828_/A _5215_/Q VPWR VGND sg13g2_dlygate4sd3_1
Xhold866 _4799_/A _5212_/Q VPWR VGND sg13g2_dlygate4sd3_1
X_3468_ _3472_/B _2754_/A _5456_/A _3634_/A VPWR VGND sg13g2_mux2_1
X_5207_ _5207_/Q _5216_/CLK _5207_/D _4947_/Y VPWR VGND sg13g2_dfrbpq_1
X_3399_ _3399_/Y _5308_/Q _3534_/A2 _3399_/B1 _5404_/Q _3397_/X VPWR VGND sg13g2_a221oi_1
XFILLER_69_372 VPWR VGND sg13g2_decap_8
XFILLER_69_361 VPWR VGND sg13g2_fill_1
X_5138_ _5138_/Y _5138_/A VPWR VGND sg13g2_inv_1
X_5069_ _5069_/Y _5112_/A VPWR VGND sg13g2_inv_1
XFILLER_72_537 VPWR VGND sg13g2_fill_1
XFILLER_72_526 VPWR VGND sg13g2_decap_8
XFILLER_25_464 VPWR VGND sg13g2_decap_8
XFILLER_80_570 VPWR VGND sg13g2_decap_8
XFILLER_52_272 VPWR VGND sg13g2_decap_8
XFILLER_40_456 VPWR VGND sg13g2_decap_4
XFILLER_32_98 VPWR VGND sg13g2_decap_4
XFILLER_0_563 VPWR VGND sg13g2_fill_2
XFILLER_57_51 VPWR VGND sg13g2_fill_1
XFILLER_57_40 VPWR VGND sg13g2_decap_8
XFILLER_48_589 VPWR VGND sg13g2_fill_1
XFILLER_28_280 VPWR VGND sg13g2_decap_8
XFILLER_16_464 VPWR VGND sg13g2_decap_8
XFILLER_16_475 VPWR VGND sg13g2_fill_1
XFILLER_73_61 VPWR VGND sg13g2_decap_8
X_2770_ _2770_/Y _2770_/A _2770_/B _2770_/C _2770_/D VPWR VGND sg13g2_nand4_1
X_4440_ _4442_/C _4440_/A _4440_/B _4440_/C _4440_/D VPWR VGND sg13g2_nand4_1
X_4371_ _5284_/D _4249_/A hold784/X _4371_/S VPWR VGND sg13g2_mux2_1
X_3322_ _3326_/A _5262_/Q _3685_/B _3666_/B _5326_/Q VPWR VGND sg13g2_a22oi_1
X_3253_ _3254_/B _3253_/A _3253_/B VPWR VGND sg13g2_xnor2_1
XFILLER_39_523 VPWR VGND sg13g2_fill_2
X_3184_ _3190_/A _4048_/A _3184_/B VPWR VGND sg13g2_nor2_1
XFILLER_14_0 VPWR VGND sg13g2_decap_8
XFILLER_39_556 VPWR VGND sg13g2_decap_8
XFILLER_66_331 VPWR VGND sg13g2_fill_2
XFILLER_66_386 VPWR VGND sg13g2_decap_8
XFILLER_19_280 VPWR VGND sg13g2_decap_8
XFILLER_34_250 VPWR VGND sg13g2_decap_8
XFILLER_62_570 VPWR VGND sg13g2_decap_8
XFILLER_22_412 VPWR VGND sg13g2_decap_4
XFILLER_22_478 VPWR VGND sg13g2_decap_8
XFILLER_22_489 VPWR VGND sg13g2_fill_1
X_2968_ _2968_/Y _4185_/B _3056_/A VPWR VGND sg13g2_nor2_1
X_4707_ _4708_/B _4697_/A _4697_/B _4700_/B VPWR VGND sg13g2_o21ai_1
X_4638_ _4638_/Y _4638_/A _5466_/A VPWR VGND sg13g2_nor2_1
X_2899_ _4440_/C _2899_/A _2899_/B VPWR VGND sg13g2_nand2_1
Xhold630 _4263_/A _5371_/Q VPWR VGND sg13g2_dlygate4sd3_1
Xhold641 _2546_/A _5376_/Q VPWR VGND sg13g2_dlygate4sd3_1
Xhold652 hold652/X _5351_/Q VPWR VGND sg13g2_dlygate4sd3_1
Xhold663 hold663/X _5183_/Q VPWR VGND sg13g2_dlygate4sd3_1
X_4569_ _4575_/C _4569_/A _4569_/B _4569_/C _4569_/D VPWR VGND sg13g2_or4_1
Xhold674 hold674/X _5304_/Q VPWR VGND sg13g2_dlygate4sd3_1
Xhold685 hold685/X _5260_/Q VPWR VGND sg13g2_dlygate4sd3_1
Xhold696 hold696/X _5354_/Q VPWR VGND sg13g2_dlygate4sd3_1
XFILLER_77_618 VPWR VGND sg13g2_fill_1
XFILLER_72_312 VPWR VGND sg13g2_decap_8
XFILLER_32_209 VPWR VGND sg13g2_decap_8
XFILLER_72_367 VPWR VGND sg13g2_fill_1
XFILLER_60_518 VPWR VGND sg13g2_decap_8
XFILLER_25_261 VPWR VGND sg13g2_decap_8
XFILLER_25_294 VPWR VGND sg13g2_decap_8
XFILLER_53_592 VPWR VGND sg13g2_decap_8
XFILLER_43_53 VPWR VGND sg13g2_decap_8
XFILLER_9_438 VPWR VGND sg13g2_decap_8
XFILLER_40_297 VPWR VGND sg13g2_fill_2
XFILLER_4_69 VPWR VGND sg13g2_fill_2
XFILLER_0_382 VPWR VGND sg13g2_decap_8
XFILLER_76_640 VPWR VGND sg13g2_fill_2
XFILLER_48_364 VPWR VGND sg13g2_fill_1
X_3940_ _3941_/D _4068_/A _3615_/X _3617_/B _3937_/Y VPWR VGND sg13g2_a22oi_1
XFILLER_63_367 VPWR VGND sg13g2_fill_1
X_3871_ _3871_/Y _3871_/A _3656_/B VPWR VGND sg13g2_nor2b_1
X_2822_ _2825_/A _5426_/Q _2870_/B _3004_/A2 _5330_/Q _2818_/Y VPWR VGND sg13g2_a221oi_1
X_2753_ _2753_/Y _5369_/Q _2927_/A2 _3400_/B1 _5337_/Q _2752_/X VPWR VGND sg13g2_a221oi_1
X_2684_ _2685_/C _2684_/A _3879_/A _2965_/C _2684_/D VPWR VGND sg13g2_nand4_1
XFILLER_8_493 VPWR VGND sg13g2_decap_4
X_4423_ _5235_/D _4353_/A hold688/X _4424_/S VPWR VGND sg13g2_mux2_1
X_4354_ _5299_/D _2901_/A _4359_/S _4353_/Y VPWR VGND sg13g2_a21oi_1
Xfanout406 _4621_/A _4572_/A VPWR VGND sg13g2_buf_1
Xfanout417 _3634_/A _3559_/S VPWR VGND sg13g2_buf_1
Xfanout428 _3936_/A _4459_/A1 VPWR VGND sg13g2_buf_1
Xfanout439 _3369_/B1 _3399_/B1 VPWR VGND sg13g2_buf_2
X_3305_ _3305_/Y _4494_/B _3318_/A2 _4178_/A2 VPWR VGND sg13g2_a21oi_1
X_4285_ _5358_/D _3796_/Y hold700/X _4294_/S VPWR VGND sg13g2_mux2_1
X_3236_ _3241_/B _4434_/A _3211_/B _3236_/B1 _4435_/B VPWR VGND sg13g2_a22oi_1
XFILLER_39_375 VPWR VGND sg13g2_decap_8
X_3167_ _3167_/Y _3210_/A _2917_/A _3211_/B _3187_/A _3166_/Y VPWR VGND sg13g2_a221oi_1
X_3098_ _3098_/X _4439_/A _3117_/B VPWR VGND sg13g2_xor2_1
XFILLER_54_345 VPWR VGND sg13g2_decap_8
XFILLER_42_507 VPWR VGND sg13g2_fill_1
XFILLER_81_153 VPWR VGND sg13g2_decap_8
XFILLER_35_570 VPWR VGND sg13g2_fill_2
XFILLER_50_551 VPWR VGND sg13g2_decap_4
XFILLER_80_18 VPWR VGND sg13g2_decap_8
XFILLER_22_253 VPWR VGND sg13g2_fill_1
XFILLER_50_595 VPWR VGND sg13g2_decap_8
XFILLER_6_419 VPWR VGND sg13g2_decap_8
XFILLER_2_614 VPWR VGND sg13g2_fill_2
XFILLER_1_113 VPWR VGND sg13g2_decap_8
XFILLER_1_157 VPWR VGND sg13g2_decap_8
XFILLER_49_117 VPWR VGND sg13g2_fill_2
XFILLER_77_415 VPWR VGND sg13g2_fill_2
XFILLER_58_651 VPWR VGND sg13g2_fill_1
XFILLER_18_526 VPWR VGND sg13g2_decap_8
XFILLER_72_175 VPWR VGND sg13g2_decap_4
XFILLER_13_253 VPWR VGND sg13g2_fill_1
Xclkload16 clkload16/Y _5216_/CLK VPWR VGND sg13g2_inv_4
XFILLER_70_84 VPWR VGND sg13g2_decap_8
XFILLER_70_73 VPWR VGND sg13g2_decap_4
XFILLER_5_463 VPWR VGND sg13g2_decap_4
XFILLER_68_426 VPWR VGND sg13g2_fill_1
X_4070_ _4071_/C _3896_/A _3506_/Y _4095_/B _4459_/A1 VPWR VGND sg13g2_a22oi_1
XFILLER_68_459 VPWR VGND sg13g2_decap_8
X_3021_ _3411_/A _3081_/B _3073_/A VPWR VGND sg13g2_nand2_1
XFILLER_24_507 VPWR VGND sg13g2_decap_8
XFILLER_24_518 VPWR VGND sg13g2_fill_2
XFILLER_63_164 VPWR VGND sg13g2_decap_8
XFILLER_36_389 VPWR VGND sg13g2_fill_2
X_4972_ _4972_/Y _5132_/A VPWR VGND sg13g2_inv_1
X_3923_ _3925_/B _3659_/Y _3923_/B VPWR VGND sg13g2_nand2b_1
X_3854_ _3854_/Y _4447_/A1 _3842_/Y _3853_/Y _4041_/A _3852_/Y VPWR VGND sg13g2_a221oi_1
X_2805_ _2805_/Y _2801_/Y _2803_/Y _2804_/Y VPWR VGND sg13g2_a21oi_1
XFILLER_81_0 VPWR VGND sg13g2_decap_8
X_3785_ _3786_/B _3878_/A _4446_/A _3785_/C VPWR VGND sg13g2_nor3_1
X_2736_ _2736_/Y _2736_/A _2736_/B _2736_/C _2736_/D VPWR VGND sg13g2_nand4_1
X_5455_ _5455_/X _5455_/A VPWR VGND sg13g2_buf_1
X_2667_ _2678_/C _2667_/A _2667_/B VPWR VGND sg13g2_nor2_1
X_4406_ _5251_/D _4059_/Y hold706/X _4407_/S VPWR VGND sg13g2_mux2_1
X_5386_ _5386_/Q clkload1/A _5386_/D _5126_/Y VPWR VGND sg13g2_dfrbpq_1
X_2598_ _2598_/Y input7/X VPWR VGND sg13g2_inv_1
Xfanout236 _4375_/S _4387_/S VPWR VGND sg13g2_buf_1
Xfanout247 _4299_/S _4311_/S VPWR VGND sg13g2_buf_1
X_4337_ _5310_/D _4178_/Y hold805/X _4357_/S VPWR VGND sg13g2_mux2_1
XFILLER_59_415 VPWR VGND sg13g2_decap_4
Xfanout258 _4013_/S _4179_/S VPWR VGND sg13g2_buf_1
Xfanout269 _4088_/B _4171_/B1 VPWR VGND sg13g2_buf_1
X_4268_ _4268_/Y _4346_/A _4282_/B VPWR VGND sg13g2_nand2_1
X_3219_ _3219_/Y input92/X _3244_/A1 _3065_/B VPWR VGND sg13g2_o21ai_1
XFILLER_74_407 VPWR VGND sg13g2_decap_8
X_4199_ _4199_/Y _4208_/B _4198_/Y _4131_/A VPWR VGND sg13g2_a21oi_1
XFILLER_55_621 VPWR VGND sg13g2_decap_4
XFILLER_24_11 VPWR VGND sg13g2_fill_1
XFILLER_50_392 VPWR VGND sg13g2_decap_8
XFILLER_6_205 VPWR VGND sg13g2_decap_8
XFILLER_10_278 VPWR VGND sg13g2_decap_4
XFILLER_2_466 VPWR VGND sg13g2_decap_8
XFILLER_2_488 VPWR VGND sg13g2_fill_1
XFILLER_49_96 VPWR VGND sg13g2_decap_8
XFILLER_1_37 VPWR VGND sg13g2_decap_8
XFILLER_77_278 VPWR VGND sg13g2_decap_8
XFILLER_65_407 VPWR VGND sg13g2_decap_8
XFILLER_61_602 VPWR VGND sg13g2_fill_1
XFILLER_33_337 VPWR VGND sg13g2_decap_8
XFILLER_45_197 VPWR VGND sg13g2_fill_2
XFILLER_60_145 VPWR VGND sg13g2_decap_8
XFILLER_14_573 VPWR VGND sg13g2_decap_4
XFILLER_81_94 VPWR VGND sg13g2_decap_8
X_3570_ _4087_/B _4113_/B _3570_/B VPWR VGND sg13g2_or2_1
X_5240_ _5240_/Q _5432_/CLK _5240_/D _4980_/Y VPWR VGND sg13g2_dfrbpq_1
X_5171_ _5171_/Y _5172_/A VPWR VGND sg13g2_inv_1
X_4122_ _4123_/D _4207_/A _4115_/Y _4121_/Y VPWR VGND sg13g2_o21ai_1
X_4053_ _4054_/C _3120_/A _4044_/Y _4052_/Y VPWR VGND sg13g2_a21oi_1
Xinput3 input3/X dmem_rdata[11] VPWR VGND sg13g2_buf_1
X_3004_ _3007_/C _5340_/Q _3004_/A2 _3004_/B1 _5404_/Q VPWR VGND sg13g2_a22oi_1
XFILLER_24_304 VPWR VGND sg13g2_decap_8
XFILLER_24_315 VPWR VGND sg13g2_fill_2
XFILLER_64_495 VPWR VGND sg13g2_fill_2
XFILLER_24_337 VPWR VGND sg13g2_decap_8
X_4955_ _4955_/Y _4959_/A VPWR VGND sg13g2_inv_1
XFILLER_51_189 VPWR VGND sg13g2_fill_1
X_3906_ _3906_/Y input83/X _3887_/B _3064_/Y VPWR VGND sg13g2_o21ai_1
X_4886_ _4886_/Y _4880_/A _4886_/B VPWR VGND sg13g2_nand2b_1
X_3837_ _4481_/A _3837_/A _3837_/B _3837_/C _3837_/D VPWR VGND sg13g2_nand4_1
XFILLER_20_598 VPWR VGND sg13g2_decap_8
X_3768_ _4204_/B _4441_/B _3768_/B _4206_/B VPWR VGND sg13g2_nand3_1
X_2719_ _2722_/B _2724_/A _2723_/C VPWR VGND sg13g2_nand2b_1
X_3699_ _3699_/Y _3829_/B _3699_/B VPWR VGND sg13g2_nand2_1
X_5438_ _5438_/X _5438_/A VPWR VGND sg13g2_buf_1
X_5369_ _5369_/Q clkload9/A _5369_/D _5109_/Y VPWR VGND sg13g2_dfrbpq_1
XFILLER_59_223 VPWR VGND sg13g2_decap_8
XFILLER_19_109 VPWR VGND sg13g2_decap_8
XFILLER_19_55 VPWR VGND sg13g2_decap_8
XFILLER_74_204 VPWR VGND sg13g2_decap_4
XFILLER_59_267 VPWR VGND sg13g2_fill_1
XFILLER_74_226 VPWR VGND sg13g2_decap_8
XFILLER_27_186 VPWR VGND sg13g2_decap_8
XFILLER_42_112 VPWR VGND sg13g2_decap_8
XFILLER_43_635 VPWR VGND sg13g2_decap_8
XFILLER_15_337 VPWR VGND sg13g2_decap_8
XFILLER_35_65 VPWR VGND sg13g2_decap_8
XFILLER_42_134 VPWR VGND sg13g2_fill_1
XFILLER_43_646 VPWR VGND sg13g2_fill_2
XFILLER_23_392 VPWR VGND sg13g2_decap_4
XFILLER_7_514 VPWR VGND sg13g2_decap_8
XFILLER_51_75 VPWR VGND sg13g2_decap_8
XFILLER_7_558 VPWR VGND sg13g2_fill_2
XFILLER_7_525 VPWR VGND sg13g2_fill_2
XFILLER_7_569 VPWR VGND sg13g2_fill_1
XFILLER_25_8 VPWR VGND sg13g2_fill_2
XFILLER_38_429 VPWR VGND sg13g2_decap_8
XFILLER_65_204 VPWR VGND sg13g2_decap_8
XFILLER_18_7 VPWR VGND sg13g2_decap_4
XFILLER_19_632 VPWR VGND sg13g2_fill_2
XFILLER_46_484 VPWR VGND sg13g2_decap_8
XFILLER_61_476 VPWR VGND sg13g2_decap_8
XFILLER_14_370 VPWR VGND sg13g2_decap_8
X_4740_ _4742_/B _4740_/A _4740_/B VPWR VGND sg13g2_xnor2_1
X_4671_ _4672_/B _4661_/B _4663_/B _4659_/Y VPWR VGND sg13g2_a21oi_1
X_3622_ _3624_/A _5190_/Q _3456_/B _3683_/A2 _5322_/Q VPWR VGND sg13g2_a22oi_1
X_3553_ _3553_/X _5179_/Q _3553_/B VPWR VGND sg13g2_and2_1
XFILLER_44_0 VPWR VGND sg13g2_decap_8
X_3484_ _5457_/A _3481_/Y _3482_/Y _3483_/Y VPWR VGND sg13g2_a21oi_1
X_5223_ _5223_/Q _5224_/CLK _5223_/D _4963_/Y VPWR VGND sg13g2_dfrbpq_1
X_5154_ _5154_/Y _5154_/A VPWR VGND sg13g2_inv_1
XFILLER_29_407 VPWR VGND sg13g2_decap_8
X_4105_ _4105_/Y _4105_/A1 _4477_/D _4104_/Y VPWR VGND sg13g2_o21ai_1
XFILLER_69_565 VPWR VGND sg13g2_decap_8
X_5085_ _5085_/Y _5150_/A VPWR VGND sg13g2_inv_1
XFILLER_56_237 VPWR VGND sg13g2_fill_1
X_4036_ _4249_/A _2609_/Y _4059_/A2 _4034_/Y _4035_/Y VPWR VGND sg13g2_a22oi_1
XFILLER_56_259 VPWR VGND sg13g2_fill_1
XFILLER_52_410 VPWR VGND sg13g2_decap_8
XFILLER_71_229 VPWR VGND sg13g2_decap_8
XFILLER_37_495 VPWR VGND sg13g2_decap_8
XFILLER_40_605 VPWR VGND sg13g2_decap_8
XFILLER_24_189 VPWR VGND sg13g2_decap_8
X_4938_ _4938_/Y _4942_/A VPWR VGND sg13g2_inv_1
X_4869_ _4886_/B _4869_/A _4869_/B VPWR VGND sg13g2_and2_1
XFILLER_20_384 VPWR VGND sg13g2_fill_1
XFILLER_4_506 VPWR VGND sg13g2_decap_8
XFILLER_21_56 VPWR VGND sg13g2_fill_1
XFILLER_21_67 VPWR VGND sg13g2_fill_2
Xoutput170 imem_addr[15] _5208_/Q VPWR VGND sg13g2_buf_1
Xoutput181 imem_addr[25] _5218_/Q VPWR VGND sg13g2_buf_1
Xoutput192 imem_addr[6] _5199_/Q VPWR VGND sg13g2_buf_1
XFILLER_47_215 VPWR VGND sg13g2_decap_8
XFILLER_75_546 VPWR VGND sg13g2_fill_2
XFILLER_75_535 VPWR VGND sg13g2_decap_8
XFILLER_55_292 VPWR VGND sg13g2_fill_2
XFILLER_31_605 VPWR VGND sg13g2_fill_1
XFILLER_11_373 VPWR VGND sg13g2_decap_8
XFILLER_7_36 VPWR VGND sg13g2_fill_1
XFILLER_7_322 VPWR VGND sg13g2_decap_8
XFILLER_3_583 VPWR VGND sg13g2_decap_8
XFILLER_19_440 VPWR VGND sg13g2_decap_8
XFILLER_19_451 VPWR VGND sg13g2_fill_2
XFILLER_81_527 VPWR VGND sg13g2_fill_2
XFILLER_34_432 VPWR VGND sg13g2_fill_2
XFILLER_34_465 VPWR VGND sg13g2_decap_4
XFILLER_21_115 VPWR VGND sg13g2_fill_2
XFILLER_34_487 VPWR VGND sg13g2_decap_8
X_2984_ _2985_/B _3011_/A _3768_/B VPWR VGND sg13g2_xnor2_1
X_4723_ _4723_/Y _4724_/A _4724_/B VPWR VGND sg13g2_nand2_1
X_4654_ _4654_/Y _4654_/A _4654_/B VPWR VGND sg13g2_xnor2_1
Xinput72 _2599_/A io_rdata[16] VPWR VGND sg13g2_buf_1
Xinput61 _4676_/A imem_data[6] VPWR VGND sg13g2_buf_1
Xinput50 input50/X imem_data[25] VPWR VGND sg13g2_buf_1
Xhold812 hold812/X _5293_/Q VPWR VGND sg13g2_dlygate4sd3_1
Xhold801 hold801/X _5344_/Q VPWR VGND sg13g2_dlygate4sd3_1
X_4585_ _4585_/Y _5451_/A _4581_/B _5452_/A VPWR VGND sg13g2_o21ai_1
X_3605_ _4446_/B _3606_/A _3606_/B _3606_/C _3606_/D VPWR VGND sg13g2_and4_1
Xinput94 input94/X io_rdata[7] VPWR VGND sg13g2_buf_1
Xinput83 input83/X io_rdata[26] VPWR VGND sg13g2_buf_1
Xhold845 _4901_/B _5223_/Q VPWR VGND sg13g2_dlygate4sd3_1
Xhold834 hold834/X _5329_/Q VPWR VGND sg13g2_dlygate4sd3_1
Xhold823 hold823/X _5326_/Q VPWR VGND sg13g2_dlygate4sd3_1
X_3536_ _3536_/Y _5280_/Q _3556_/A2 _3556_/B1 _5344_/Q _3535_/Y VPWR VGND sg13g2_a221oi_1
Xhold889 _4721_/B _4720_/Y VPWR VGND sg13g2_dlygate4sd3_1
Xhold878 _4788_/A _5211_/Q VPWR VGND sg13g2_dlygate4sd3_1
Xhold867 _4800_/B _4802_/B VPWR VGND sg13g2_dlygate4sd3_1
Xhold856 _4856_/B _5217_/Q VPWR VGND sg13g2_dlygate4sd3_1
X_5206_ _5206_/Q _5206_/CLK _5206_/D _4946_/Y VPWR VGND sg13g2_dfrbpq_1
X_3467_ _5456_/A _3467_/A _3467_/B _3467_/C _3467_/D VPWR VGND sg13g2_nand4_1
X_3398_ _3398_/Y _2549_/Y _3368_/B _3398_/B1 VPWR VGND sg13g2_o21ai_1
X_5137_ _5137_/Y _5170_/A VPWR VGND sg13g2_inv_1
XFILLER_57_524 VPWR VGND sg13g2_decap_8
X_5068_ _5068_/Y _5164_/A VPWR VGND sg13g2_inv_1
XFILLER_72_505 VPWR VGND sg13g2_decap_8
X_4019_ _4024_/A _4068_/A _4019_/B _4019_/C VPWR VGND sg13g2_nand3_1
XFILLER_16_34 VPWR VGND sg13g2_decap_4
XFILLER_25_443 VPWR VGND sg13g2_decap_8
XFILLER_72_549 VPWR VGND sg13g2_decap_8
XFILLER_52_251 VPWR VGND sg13g2_decap_8
XFILLER_12_126 VPWR VGND sg13g2_fill_1
XFILLER_25_487 VPWR VGND sg13g2_fill_1
XFILLER_25_498 VPWR VGND sg13g2_fill_2
XFILLER_8_108 VPWR VGND sg13g2_decap_8
XFILLER_32_66 VPWR VGND sg13g2_decap_4
XFILLER_4_303 VPWR VGND sg13g2_fill_1
XFILLER_0_542 VPWR VGND sg13g2_decap_8
XFILLER_63_527 VPWR VGND sg13g2_fill_1
XFILLER_73_40 VPWR VGND sg13g2_fill_2
XFILLER_56_590 VPWR VGND sg13g2_decap_8
XFILLER_16_443 VPWR VGND sg13g2_decap_8
XFILLER_31_424 VPWR VGND sg13g2_decap_4
XFILLER_43_284 VPWR VGND sg13g2_fill_2
XFILLER_43_295 VPWR VGND sg13g2_fill_1
XFILLER_8_620 VPWR VGND sg13g2_decap_8
XFILLER_11_170 VPWR VGND sg13g2_decap_8
XFILLER_11_181 VPWR VGND sg13g2_fill_1
XFILLER_7_163 VPWR VGND sg13g2_decap_8
X_4370_ _5285_/D _4012_/Y hold747/X _4371_/S VPWR VGND sg13g2_mux2_1
X_3321_ _3321_/Y _4394_/A _4394_/B _4238_/C VPWR VGND sg13g2_nor3_1
X_3252_ _3262_/B _4133_/A _3252_/B VPWR VGND sg13g2_nand2_1
X_3183_ _3193_/A _3191_/A _3206_/B _3163_/Y VPWR VGND sg13g2_o21ai_1
XFILLER_39_546 VPWR VGND sg13g2_decap_4
XFILLER_39_579 VPWR VGND sg13g2_fill_2
XFILLER_54_527 VPWR VGND sg13g2_fill_2
XFILLER_19_270 VPWR VGND sg13g2_decap_4
XFILLER_47_590 VPWR VGND sg13g2_decap_8
XFILLER_54_549 VPWR VGND sg13g2_decap_8
XFILLER_34_284 VPWR VGND sg13g2_decap_8
XFILLER_62_593 VPWR VGND sg13g2_fill_1
XFILLER_22_468 VPWR VGND sg13g2_fill_2
X_2967_ _3056_/A _3057_/A _3057_/C VPWR VGND sg13g2_nand2_1
X_4706_ _4730_/B _4706_/A _4706_/B VPWR VGND sg13g2_xor2_1
X_2898_ _2899_/B _5235_/Q _2938_/B _3003_/B1 _5267_/Q _2894_/Y VPWR VGND sg13g2_a221oi_1
X_4637_ _4637_/Y _5465_/A _4639_/C _4635_/Y VPWR VGND sg13g2_o21ai_1
Xhold620 _2563_/A _5298_/Q VPWR VGND sg13g2_dlygate4sd3_1
Xhold631 _2541_/A _5401_/Q VPWR VGND sg13g2_dlygate4sd3_1
Xhold642 _2564_/A _5231_/Q VPWR VGND sg13g2_dlygate4sd3_1
Xhold653 hold653/X _5286_/Q VPWR VGND sg13g2_dlygate4sd3_1
X_4568_ _4569_/D _4568_/A _4568_/B _4568_/C VPWR VGND sg13g2_or3_1
XFILLER_78_18 VPWR VGND sg13g2_decap_8
XFILLER_1_317 VPWR VGND sg13g2_fill_2
Xhold664 hold664/X _5279_/Q VPWR VGND sg13g2_dlygate4sd3_1
Xhold675 hold675/X _5263_/Q VPWR VGND sg13g2_dlygate4sd3_1
Xhold686 hold686/X _5319_/Q VPWR VGND sg13g2_dlygate4sd3_1
Xhold697 hold697/X _5392_/Q VPWR VGND sg13g2_dlygate4sd3_1
X_4499_ _5225_/D _4499_/A _4499_/B VPWR VGND sg13g2_xnor2_1
X_3519_ _3520_/D _5281_/Q _3688_/B1 _3555_/B1 _5409_/Q VPWR VGND sg13g2_a22oi_1
XFILLER_76_129 VPWR VGND sg13g2_decap_8
XFILLER_72_302 VPWR VGND sg13g2_decap_4
XFILLER_57_387 VPWR VGND sg13g2_decap_8
XFILLER_57_365 VPWR VGND sg13g2_fill_2
XFILLER_17_229 VPWR VGND sg13g2_decap_8
XFILLER_38_590 VPWR VGND sg13g2_decap_8
XFILLER_72_357 VPWR VGND sg13g2_decap_4
XFILLER_13_402 VPWR VGND sg13g2_decap_4
XFILLER_53_571 VPWR VGND sg13g2_decap_8
XFILLER_9_406 VPWR VGND sg13g2_decap_8
XFILLER_21_490 VPWR VGND sg13g2_decap_8
Xclkbuf_leaf_20_clk clkload2/A clkbuf_2_0__f_clk/X VPWR VGND sg13g2_buf_8
XFILLER_5_634 VPWR VGND sg13g2_decap_8
XFILLER_4_166 VPWR VGND sg13g2_decap_8
XFILLER_4_37 VPWR VGND sg13g2_fill_2
XFILLER_68_608 VPWR VGND sg13g2_fill_1
XFILLER_68_84 VPWR VGND sg13g2_decap_8
XFILLER_48_343 VPWR VGND sg13g2_decap_8
XFILLER_76_630 VPWR VGND sg13g2_fill_2
XFILLER_48_376 VPWR VGND sg13g2_decap_8
XFILLER_63_313 VPWR VGND sg13g2_fill_1
XFILLER_29_590 VPWR VGND sg13g2_decap_8
XFILLER_63_335 VPWR VGND sg13g2_fill_2
XFILLER_63_357 VPWR VGND sg13g2_fill_2
XFILLER_44_582 VPWR VGND sg13g2_decap_8
XFILLER_31_243 VPWR VGND sg13g2_decap_4
X_3870_ _3871_/A _3893_/B _3862_/Y _4041_/A VPWR VGND sg13g2_o21ai_1
X_2821_ _2823_/D _2826_/A _2894_/B VPWR VGND sg13g2_or2_1
XFILLER_12_490 VPWR VGND sg13g2_decap_4
Xclkbuf_leaf_11_clk _5432_/CLK clkbuf_2_3__f_clk/X VPWR VGND sg13g2_buf_8
X_2752_ _2752_/X _5433_/Q _3627_/B _2712_/Y VPWR VGND sg13g2_a21o_1
XFILLER_8_472 VPWR VGND sg13g2_decap_8
X_4422_ _5236_/D _4351_/A hold693/X _4425_/S VPWR VGND sg13g2_mux2_1
X_2683_ _2684_/D _2671_/B _2656_/B _4638_/A VPWR VGND sg13g2_a21oi_1
X_4353_ _4353_/Y _4353_/A _4359_/S VPWR VGND sg13g2_nor2_1
Xfanout407 _4638_/A _4572_/A VPWR VGND sg13g2_buf_1
Xfanout418 _3559_/S _2656_/Y VPWR VGND sg13g2_buf_1
Xfanout429 _4459_/A1 _2999_/Y VPWR VGND sg13g2_buf_1
X_4284_ _4284_/Y _4238_/C _4360_/B _4394_/A VPWR VGND sg13g2_nand3b_1
X_3304_ _3304_/Y _4146_/A2 _4470_/C _3303_/Y VPWR VGND sg13g2_o21ai_1
X_3235_ _3241_/A _4440_/C _3025_/B _4094_/B1 VPWR VGND sg13g2_o21ai_1
XFILLER_27_505 VPWR VGND sg13g2_fill_1
XFILLER_39_354 VPWR VGND sg13g2_decap_8
X_3166_ _3166_/Y _3166_/A _3166_/B VPWR VGND sg13g2_nor2_1
X_3097_ _3097_/Y _3102_/B _3097_/B VPWR VGND sg13g2_xnor2_1
XFILLER_66_195 VPWR VGND sg13g2_fill_2
XFILLER_81_143 VPWR VGND sg13g2_fill_1
XFILLER_54_368 VPWR VGND sg13g2_fill_1
XFILLER_50_530 VPWR VGND sg13g2_decap_8
X_3999_ _3999_/Y _4020_/A _3999_/B VPWR VGND sg13g2_nor2_1
XFILLER_10_449 VPWR VGND sg13g2_decap_8
XFILLER_22_287 VPWR VGND sg13g2_decap_8
XFILLER_58_630 VPWR VGND sg13g2_decap_8
XFILLER_45_302 VPWR VGND sg13g2_decap_8
XFILLER_73_633 VPWR VGND sg13g2_decap_8
XFILLER_72_198 VPWR VGND sg13g2_decap_8
XFILLER_41_552 VPWR VGND sg13g2_fill_1
XFILLER_41_574 VPWR VGND sg13g2_fill_1
XFILLER_9_214 VPWR VGND sg13g2_decap_4
XFILLER_9_236 VPWR VGND sg13g2_decap_4
XFILLER_70_52 VPWR VGND sg13g2_fill_2
XFILLER_5_431 VPWR VGND sg13g2_decap_8
XFILLER_48_7 VPWR VGND sg13g2_decap_4
XFILLER_5_497 VPWR VGND sg13g2_decap_8
XFILLER_68_438 VPWR VGND sg13g2_decap_8
Xclkbuf_leaf_0_clk clkload5/A clkbuf_leaf_3_clk/A VPWR VGND sg13g2_buf_8
X_3020_ _3020_/Y _3081_/B _3018_/Y _3019_/Y VPWR VGND sg13g2_a21oi_1
XFILLER_48_184 VPWR VGND sg13g2_decap_4
XFILLER_63_143 VPWR VGND sg13g2_decap_8
XFILLER_17_571 VPWR VGND sg13g2_decap_8
XFILLER_51_305 VPWR VGND sg13g2_decap_8
X_4971_ _4971_/Y _5132_/A VPWR VGND sg13g2_inv_1
X_3922_ _3923_/B _3580_/Y _3736_/B _3916_/B VPWR VGND sg13g2_a21oi_1
X_3853_ _3853_/Y _3855_/B _3853_/B VPWR VGND sg13g2_xnor2_1
X_2804_ _2804_/Y _5236_/Q _3365_/A2 _3365_/B1 VPWR VGND sg13g2_a21oi_1
X_3784_ _3790_/B _4045_/A _3783_/Y _4463_/A VPWR VGND sg13g2_a21oi_1
XFILLER_74_0 VPWR VGND sg13g2_decap_8
X_2735_ _3773_/A _2736_/A _2736_/B _2736_/C _2736_/D VPWR VGND sg13g2_and4_1
X_5454_ _5454_/X _5454_/A VPWR VGND sg13g2_buf_1
X_2666_ _2684_/A _2666_/A _3295_/A _2666_/C _4462_/A VPWR VGND sg13g2_nor4_1
X_5385_ _5385_/Q clkload3/A _5385_/D _5125_/Y VPWR VGND sg13g2_dfrbpq_1
X_4405_ _5252_/D _4249_/A hold794/X _4407_/S VPWR VGND sg13g2_mux2_1
X_4336_ _5311_/D _2557_/Y _4335_/B _4335_/Y VPWR VGND sg13g2_a21oi_1
X_2597_ _2597_/Y _2597_/A VPWR VGND sg13g2_inv_1
Xfanout237 _4388_/S _4387_/S VPWR VGND sg13g2_buf_1
Xfanout248 _4312_/S _4317_/S VPWR VGND sg13g2_buf_1
Xfanout259 _4224_/B _4179_/S VPWR VGND sg13g2_buf_1
X_4267_ _5368_/D hold748/X _3136_/Y _4273_/S VPWR VGND sg13g2_mux2_1
X_4198_ _4198_/Y _4198_/A _4198_/B VPWR VGND sg13g2_nand2_1
X_3218_ _4471_/B _3200_/Y _3202_/Y _3204_/Y _4133_/A _3217_/Y VPWR VGND sg13g2_a221oi_1
XFILLER_27_313 VPWR VGND sg13g2_decap_8
XFILLER_27_335 VPWR VGND sg13g2_fill_1
X_3149_ _3149_/Y _3209_/A1 _3142_/B _3148_/Y _4074_/A1 _3147_/Y VPWR VGND sg13g2_a221oi_1
XFILLER_67_493 VPWR VGND sg13g2_fill_1
XFILLER_27_357 VPWR VGND sg13g2_fill_2
XFILLER_27_368 VPWR VGND sg13g2_fill_1
XFILLER_54_165 VPWR VGND sg13g2_decap_8
XFILLER_24_23 VPWR VGND sg13g2_decap_8
XFILLER_24_34 VPWR VGND sg13g2_fill_1
XFILLER_23_596 VPWR VGND sg13g2_decap_4
XFILLER_40_44 VPWR VGND sg13g2_fill_1
XFILLER_6_228 VPWR VGND sg13g2_fill_1
XFILLER_49_42 VPWR VGND sg13g2_decap_8
XFILLER_49_75 VPWR VGND sg13g2_decap_8
XFILLER_1_16 VPWR VGND sg13g2_decap_8
XFILLER_18_313 VPWR VGND sg13g2_fill_1
XFILLER_46_644 VPWR VGND sg13g2_decap_8
XFILLER_65_41 VPWR VGND sg13g2_fill_1
XFILLER_18_357 VPWR VGND sg13g2_decap_8
XFILLER_73_452 VPWR VGND sg13g2_decap_4
XFILLER_65_85 VPWR VGND sg13g2_fill_2
XFILLER_26_390 VPWR VGND sg13g2_decap_8
XFILLER_14_552 VPWR VGND sg13g2_decap_8
XFILLER_81_73 VPWR VGND sg13g2_decap_8
XFILLER_5_272 VPWR VGND sg13g2_fill_2
XFILLER_5_294 VPWR VGND sg13g2_decap_8
X_5170_ _5170_/Y _5170_/A VPWR VGND sg13g2_inv_1
XFILLER_68_213 VPWR VGND sg13g2_decap_8
X_4121_ _4121_/Y _4441_/A _4114_/Y _4115_/Y _4433_/A VPWR VGND sg13g2_a22oi_1
X_4052_ _4052_/Y _3239_/A _4044_/Y _4051_/Y VPWR VGND sg13g2_o21ai_1
Xinput4 input4/X dmem_rdata[12] VPWR VGND sg13g2_buf_1
X_3003_ _3007_/B _5372_/Q _3003_/A2 _3003_/B1 _5276_/Q VPWR VGND sg13g2_a22oi_1
Xclkbuf_2_1__f_clk clkbuf_leaf_3_clk/A clkbuf_0_clk/X VPWR VGND sg13g2_buf_16
XFILLER_51_135 VPWR VGND sg13g2_decap_4
X_4954_ _4954_/Y _4954_/A VPWR VGND sg13g2_inv_1
X_3905_ _4478_/B _3905_/A _3905_/B _3905_/C VPWR VGND sg13g2_nor3_1
X_4885_ _4885_/X _4885_/A _4885_/B VPWR VGND sg13g2_or2_1
XFILLER_20_555 VPWR VGND sg13g2_decap_4
X_3836_ _3837_/D _3836_/A _3836_/B _3836_/C _3836_/D VPWR VGND sg13g2_nor4_1
X_3767_ _3771_/B _4450_/A _4448_/C VPWR VGND sg13g2_nand2_1
X_2718_ _2941_/B _2723_/B _2754_/A _2723_/C VPWR VGND sg13g2_nand3b_1
X_3698_ _3699_/B _3855_/B VPWR VGND sg13g2_inv_1
X_5437_ _5437_/X _5437_/A VPWR VGND sg13g2_buf_1
X_2649_ _2649_/Y _2956_/C _2999_/B _2670_/D VPWR VGND sg13g2_nor3_1
X_5368_ _5368_/Q _5432_/CLK _5368_/D _5108_/Y VPWR VGND sg13g2_dfrbpq_1
X_5299_ _5299_/Q _5426_/CLK _5299_/D _5039_/Y VPWR VGND sg13g2_dfrbpq_1
X_4319_ _4319_/Y _2688_/B _4394_/C VPWR VGND sg13g2_nand2b_1
XFILLER_19_34 VPWR VGND sg13g2_decap_8
XFILLER_47_419 VPWR VGND sg13g2_decap_8
XFILLER_27_110 VPWR VGND sg13g2_decap_8
XFILLER_27_121 VPWR VGND sg13g2_fill_2
XFILLER_35_44 VPWR VGND sg13g2_decap_8
XFILLER_30_319 VPWR VGND sg13g2_decap_8
XFILLER_42_179 VPWR VGND sg13g2_decap_4
XFILLER_11_522 VPWR VGND sg13g2_decap_4
XFILLER_11_544 VPWR VGND sg13g2_decap_8
XFILLER_11_588 VPWR VGND sg13g2_fill_2
XFILLER_4_0 VPWR VGND sg13g2_decap_8
XFILLER_78_500 VPWR VGND sg13g2_decap_8
XFILLER_78_544 VPWR VGND sg13g2_fill_2
Xfanout590 _4603_/A1 input45/X VPWR VGND sg13g2_buf_1
XFILLER_65_227 VPWR VGND sg13g2_fill_1
XFILLER_33_102 VPWR VGND sg13g2_fill_1
XFILLER_34_603 VPWR VGND sg13g2_decap_8
XFILLER_34_614 VPWR VGND sg13g2_fill_1
XFILLER_46_463 VPWR VGND sg13g2_decap_8
XFILLER_61_411 VPWR VGND sg13g2_decap_4
XFILLER_33_113 VPWR VGND sg13g2_fill_1
XFILLER_61_466 VPWR VGND sg13g2_fill_2
X_4670_ _4672_/A _4670_/A _4670_/B VPWR VGND sg13g2_xnor2_1
X_3621_ _3626_/B _5386_/Q _3492_/B _3668_/B1 _5290_/Q VPWR VGND sg13g2_a22oi_1
X_3552_ _3552_/Y _3552_/A _3552_/B VPWR VGND sg13g2_nand2_1
XFILLER_51_2 VPWR VGND sg13g2_fill_1
X_3483_ _3483_/Y _5252_/Q _2754_/A _3692_/A2 VPWR VGND sg13g2_a21oi_1
X_5222_ _5222_/Q _5224_/CLK _5222_/D _4962_/Y VPWR VGND sg13g2_dfrbpq_1
XFILLER_69_511 VPWR VGND sg13g2_decap_8
XFILLER_37_0 VPWR VGND sg13g2_decap_8
X_5153_ _5153_/Y _5153_/A VPWR VGND sg13g2_inv_1
X_4104_ _4104_/Y _2603_/Y _2685_/B _4177_/A2 VPWR VGND sg13g2_a21oi_1
X_5084_ _5084_/Y _5092_/A VPWR VGND sg13g2_inv_1
XFILLER_69_599 VPWR VGND sg13g2_decap_8
XFILLER_56_216 VPWR VGND sg13g2_decap_8
XFILLER_37_452 VPWR VGND sg13g2_decap_8
X_4035_ _4035_/Y _2716_/A _2666_/C _4059_/A2 VPWR VGND sg13g2_a21oi_1
XFILLER_25_603 VPWR VGND sg13g2_fill_1
XFILLER_24_113 VPWR VGND sg13g2_decap_8
XFILLER_24_124 VPWR VGND sg13g2_fill_2
XFILLER_52_477 VPWR VGND sg13g2_decap_8
X_4937_ _4937_/Y _4942_/A VPWR VGND sg13g2_inv_1
XFILLER_20_330 VPWR VGND sg13g2_fill_1
X_4868_ _4871_/B _4849_/A _4849_/B _4867_/Y VPWR VGND sg13g2_o21ai_1
XFILLER_20_363 VPWR VGND sg13g2_decap_8
X_3819_ _3856_/B _3855_/A _3855_/B VPWR VGND sg13g2_nor2_1
XFILLER_20_396 VPWR VGND sg13g2_decap_8
X_4799_ _4802_/B _4799_/A _4799_/B VPWR VGND sg13g2_xnor2_1
XFILLER_21_79 VPWR VGND sg13g2_fill_1
Xoutput160 dmem_wdata[7] _5443_/A VPWR VGND sg13g2_buf_1
Xoutput171 imem_addr[16] _5209_/Q VPWR VGND sg13g2_buf_1
Xoutput182 imem_addr[26] _5219_/Q VPWR VGND sg13g2_buf_1
Xoutput193 imem_addr[7] _5200_/Q VPWR VGND sg13g2_buf_1
XFILLER_46_43 VPWR VGND sg13g2_decap_4
XFILLER_62_208 VPWR VGND sg13g2_decap_8
XFILLER_15_102 VPWR VGND sg13g2_decap_8
XFILLER_15_146 VPWR VGND sg13g2_decap_4
XFILLER_62_42 VPWR VGND sg13g2_decap_8
XFILLER_30_149 VPWR VGND sg13g2_fill_2
XFILLER_11_352 VPWR VGND sg13g2_decap_8
XFILLER_7_312 VPWR VGND sg13g2_fill_1
XFILLER_7_26 VPWR VGND sg13g2_fill_1
XFILLER_7_59 VPWR VGND sg13g2_decap_8
XFILLER_30_7 VPWR VGND sg13g2_decap_4
XFILLER_66_558 VPWR VGND sg13g2_decap_8
XFILLER_53_208 VPWR VGND sg13g2_decap_8
XFILLER_19_496 VPWR VGND sg13g2_fill_1
XFILLER_34_444 VPWR VGND sg13g2_decap_8
XFILLER_22_628 VPWR VGND sg13g2_decap_8
X_2983_ _2983_/Y _4441_/B _3768_/B VPWR VGND sg13g2_nand2_1
XFILLER_61_285 VPWR VGND sg13g2_decap_8
XFILLER_14_190 VPWR VGND sg13g2_fill_2
XFILLER_21_138 VPWR VGND sg13g2_decap_4
X_4722_ _4722_/Y _4745_/S _4724_/B VPWR VGND sg13g2_nor2b_1
Xinput40 input40/X imem_data[16] VPWR VGND sg13g2_buf_1
X_4653_ _4654_/B _4646_/A _4646_/B _4643_/Y VPWR VGND sg13g2_a21oi_1
Xinput73 _2601_/A io_rdata[17] VPWR VGND sg13g2_buf_1
Xinput62 _4688_/A imem_data[7] VPWR VGND sg13g2_buf_1
Xinput51 _4523_/B imem_data[26] VPWR VGND sg13g2_buf_1
Xhold802 hold802/X _5336_/Q VPWR VGND sg13g2_dlygate4sd3_1
X_4584_ _4590_/B _5451_/A _5452_/A _4584_/C VPWR VGND sg13g2_nor3_2
X_3604_ _3606_/D _5383_/Q _3492_/B _3668_/A2 _5351_/Q VPWR VGND sg13g2_a22oi_1
Xinput95 input95/X io_rdata[8] VPWR VGND sg13g2_buf_1
Xinput84 _3887_/A io_rdata[27] VPWR VGND sg13g2_buf_1
Xhold846 hold846/X _4900_/Y VPWR VGND sg13g2_dlygate4sd3_1
Xhold835 hold835/X _5290_/Q VPWR VGND sg13g2_dlygate4sd3_1
Xhold824 hold824/X _5412_/Q VPWR VGND sg13g2_dlygate4sd3_1
Xhold813 hold813/X _5182_/Q VPWR VGND sg13g2_dlygate4sd3_1
X_3535_ _3535_/Y _2546_/Y _3386_/B _2754_/B VPWR VGND sg13g2_o21ai_1
Xhold879 _4789_/B _4791_/B VPWR VGND sg13g2_dlygate4sd3_1
Xhold868 _4911_/A _5224_/Q VPWR VGND sg13g2_dlygate4sd3_1
Xhold857 hold857/X _4851_/B VPWR VGND sg13g2_dlygate4sd3_1
X_3466_ _3467_/D _5251_/Q _3677_/B _3627_/B _5183_/Q VPWR VGND sg13g2_a22oi_1
X_5205_ _5205_/Q _5206_/CLK _5205_/D _4945_/Y VPWR VGND sg13g2_dfrbpq_1
X_3397_ _3397_/X _5176_/Q _3397_/B VPWR VGND sg13g2_and2_1
XFILLER_57_503 VPWR VGND sg13g2_decap_8
XFILLER_29_205 VPWR VGND sg13g2_decap_8
X_5136_ _5136_/Y _5175_/A VPWR VGND sg13g2_inv_1
XFILLER_69_396 VPWR VGND sg13g2_decap_8
X_5067_ _5067_/Y _5164_/A VPWR VGND sg13g2_inv_1
XFILLER_57_558 VPWR VGND sg13g2_decap_8
XFILLER_44_219 VPWR VGND sg13g2_fill_2
X_4018_ _4018_/Y _4448_/C _4018_/B VPWR VGND sg13g2_xnor2_1
XFILLER_37_293 VPWR VGND sg13g2_fill_2
XFILLER_52_230 VPWR VGND sg13g2_decap_8
XFILLER_0_521 VPWR VGND sg13g2_decap_8
XFILLER_0_565 VPWR VGND sg13g2_fill_1
XFILLER_0_598 VPWR VGND sg13g2_decap_8
XFILLER_48_558 VPWR VGND sg13g2_decap_8
XFILLER_75_344 VPWR VGND sg13g2_decap_8
XFILLER_75_377 VPWR VGND sg13g2_fill_2
XFILLER_63_517 VPWR VGND sg13g2_decap_4
XFILLER_75_399 VPWR VGND sg13g2_decap_8
XFILLER_71_550 VPWR VGND sg13g2_decap_8
XFILLER_16_488 VPWR VGND sg13g2_decap_8
XFILLER_71_594 VPWR VGND sg13g2_decap_8
XFILLER_31_447 VPWR VGND sg13g2_decap_8
XFILLER_8_643 VPWR VGND sg13g2_fill_1
XFILLER_78_7 VPWR VGND sg13g2_decap_8
X_3320_ _5423_/D hold651/X _4427_/A _4518_/S VPWR VGND sg13g2_mux2_1
X_3251_ _3252_/B _3251_/A _3251_/B VPWR VGND sg13g2_xnor2_1
XFILLER_39_525 VPWR VGND sg13g2_fill_1
X_3182_ _3182_/Y _3182_/A _3182_/B VPWR VGND sg13g2_xnor2_1
XFILLER_78_171 VPWR VGND sg13g2_decap_8
XFILLER_66_333 VPWR VGND sg13g2_fill_1
XFILLER_54_506 VPWR VGND sg13g2_decap_8
XFILLER_10_609 VPWR VGND sg13g2_fill_2
XFILLER_22_447 VPWR VGND sg13g2_decap_8
X_2966_ _3057_/C _3010_/C _3010_/D VPWR VGND sg13g2_nor2_1
XFILLER_30_491 VPWR VGND sg13g2_fill_1
X_4705_ _4729_/A _4706_/A _4705_/B VPWR VGND sg13g2_nor2_1
X_2897_ _2899_/A _5363_/Q _3003_/A2 _3004_/A2 _5331_/Q _2896_/Y VPWR VGND sg13g2_a221oi_1
X_4636_ _4636_/Y _5465_/A _4639_/C VPWR VGND sg13g2_nor2_1
Xhold621 _2561_/A _5300_/Q VPWR VGND sg13g2_dlygate4sd3_1
Xhold632 _4458_/A _5229_/Q VPWR VGND sg13g2_dlygate4sd3_1
Xhold643 _2549_/A _5372_/Q VPWR VGND sg13g2_dlygate4sd3_1
Xhold654 hold654/X _5178_/Q VPWR VGND sg13g2_dlygate4sd3_1
X_4567_ _4575_/D _4567_/A VPWR VGND sg13g2_inv_1
Xhold665 hold665/X _5295_/Q VPWR VGND sg13g2_dlygate4sd3_1
Xhold676 hold676/X _5430_/Q VPWR VGND sg13g2_dlygate4sd3_1
Xhold687 hold687/X _5297_/Q VPWR VGND sg13g2_dlygate4sd3_1
X_4498_ _4499_/B _4524_/A _4664_/A VPWR VGND sg13g2_nand2_1
X_3518_ _3520_/C _5377_/Q _3687_/B _3553_/B _5181_/Q VPWR VGND sg13g2_a22oi_1
Xhold698 hold698/X _5398_/Q VPWR VGND sg13g2_dlygate4sd3_1
X_3449_ _3453_/B _2694_/B _5459_/A _3634_/A VPWR VGND sg13g2_mux2_1
X_5119_ _5119_/Y _5149_/A VPWR VGND sg13g2_inv_1
XFILLER_57_333 VPWR VGND sg13g2_fill_2
XFILLER_57_322 VPWR VGND sg13g2_decap_8
XFILLER_17_208 VPWR VGND sg13g2_decap_8
XFILLER_45_506 VPWR VGND sg13g2_fill_2
XFILLER_45_528 VPWR VGND sg13g2_decap_8
XFILLER_57_377 VPWR VGND sg13g2_fill_1
XFILLER_53_550 VPWR VGND sg13g2_decap_8
XFILLER_13_447 VPWR VGND sg13g2_decap_4
XFILLER_13_458 VPWR VGND sg13g2_fill_1
XFILLER_43_33 VPWR VGND sg13g2_fill_2
XFILLER_5_613 VPWR VGND sg13g2_decap_8
XFILLER_4_123 VPWR VGND sg13g2_decap_8
XFILLER_4_134 VPWR VGND sg13g2_fill_2
XFILLER_4_145 VPWR VGND sg13g2_decap_8
XFILLER_76_642 VPWR VGND sg13g2_fill_1
XFILLER_36_528 VPWR VGND sg13g2_decap_4
XFILLER_36_539 VPWR VGND sg13g2_decap_8
XFILLER_44_561 VPWR VGND sg13g2_decap_8
X_2820_ _2823_/C _2895_/D _2820_/B _5266_/Q VPWR VGND sg13g2_nand3b_1
X_2751_ _2751_/Y _5305_/Q _2879_/A2 _3400_/A2 _5273_/Q _2750_/Y VPWR VGND sg13g2_a221oi_1
X_2682_ _2682_/Y _3000_/A _2682_/B _4521_/C VPWR VGND sg13g2_nand3_1
X_4421_ _5237_/D _3198_/Y hold648/X _4424_/S VPWR VGND sg13g2_mux2_1
X_4352_ _5300_/D _2561_/Y _4351_/B _4351_/Y VPWR VGND sg13g2_a21oi_1
Xfanout408 _4559_/B _4572_/A VPWR VGND sg13g2_buf_1
Xfanout419 _3403_/S _2656_/Y VPWR VGND sg13g2_buf_1
X_4283_ _5359_/D _2556_/Y _4282_/B _4282_/Y VPWR VGND sg13g2_o21ai_1
X_3303_ _3303_/Y _2579_/Y _4146_/A2 _3318_/A2 VPWR VGND sg13g2_a21oi_1
X_3234_ _3242_/C _3234_/A _3234_/B VPWR VGND sg13g2_nor2_1
X_3165_ _3169_/A _4212_/A1 _2916_/B _3164_/Y VPWR VGND sg13g2_o21ai_1
XFILLER_27_528 VPWR VGND sg13g2_decap_8
X_3096_ _3109_/A _3269_/B _3096_/B _3096_/C VPWR VGND sg13g2_nand3_1
XFILLER_81_122 VPWR VGND sg13g2_decap_8
XFILLER_66_174 VPWR VGND sg13g2_decap_8
XFILLER_22_200 VPWR VGND sg13g2_fill_1
XFILLER_81_188 VPWR VGND sg13g2_fill_2
XFILLER_22_211 VPWR VGND sg13g2_fill_2
XFILLER_35_594 VPWR VGND sg13g2_decap_8
XFILLER_22_244 VPWR VGND sg13g2_decap_8
XFILLER_22_266 VPWR VGND sg13g2_fill_1
XFILLER_50_564 VPWR VGND sg13g2_decap_4
X_3998_ _3998_/Y _3756_/A _3435_/B _3896_/A VPWR VGND sg13g2_o21ai_1
XFILLER_13_47 VPWR VGND sg13g2_decap_8
X_2949_ _3048_/B _3144_/A _3023_/A VPWR VGND sg13g2_xnor2_1
X_4619_ _4620_/C _5460_/A _4619_/B _4623_/D VPWR VGND sg13g2_nand3_1
XFILLER_2_616 VPWR VGND sg13g2_fill_1
XFILLER_2_649 VPWR VGND sg13g2_fill_2
XFILLER_77_406 VPWR VGND sg13g2_fill_2
XFILLER_38_99 VPWR VGND sg13g2_decap_8
XFILLER_45_336 VPWR VGND sg13g2_decap_8
XFILLER_72_111 VPWR VGND sg13g2_decap_4
XFILLER_72_188 VPWR VGND sg13g2_decap_8
XFILLER_60_328 VPWR VGND sg13g2_decap_8
XFILLER_54_65 VPWR VGND sg13g2_decap_8
XFILLER_53_391 VPWR VGND sg13g2_fill_1
XFILLER_53_380 VPWR VGND sg13g2_decap_8
XFILLER_41_597 VPWR VGND sg13g2_decap_8
XFILLER_70_20 VPWR VGND sg13g2_decap_8
XFILLER_48_152 VPWR VGND sg13g2_decap_8
XFILLER_76_450 VPWR VGND sg13g2_decap_8
XFILLER_64_623 VPWR VGND sg13g2_fill_2
XFILLER_64_612 VPWR VGND sg13g2_fill_1
XFILLER_63_111 VPWR VGND sg13g2_fill_2
X_4970_ _4970_/Y _5001_/A VPWR VGND sg13g2_inv_1
XFILLER_32_520 VPWR VGND sg13g2_decap_8
X_3921_ _3921_/Y _3921_/A _3921_/B VPWR VGND sg13g2_nor2_1
X_3852_ _3852_/Y _3921_/A _3842_/Y _3851_/Y VPWR VGND sg13g2_o21ai_1
X_2803_ _2803_/Y _5332_/Q _3363_/A2 _3363_/B1 _5268_/Q _2802_/Y VPWR VGND sg13g2_a221oi_1
X_3783_ _3783_/Y _3938_/A _3765_/A _3342_/B _4068_/A VPWR VGND sg13g2_a22oi_1
X_2734_ _2736_/D _5434_/Q _2800_/B _3363_/A2 _5338_/Q VPWR VGND sg13g2_a22oi_1
X_5453_ _5453_/X _5453_/A VPWR VGND sg13g2_buf_1
X_2665_ _4433_/B _2665_/A _2665_/B VPWR VGND sg13g2_nand2_1
X_5384_ _5384_/Q clkload1/A _5384_/D _5124_/Y VPWR VGND sg13g2_dfrbpq_1
X_4404_ _5253_/D _4012_/Y hold736/X _4407_/S VPWR VGND sg13g2_mux2_1
X_2596_ _2596_/Y input6/X VPWR VGND sg13g2_inv_1
X_4335_ _4335_/Y _4335_/A _4335_/B VPWR VGND sg13g2_nor2_1
Xfanout238 _4393_/S _4387_/S VPWR VGND sg13g2_buf_1
XFILLER_59_406 VPWR VGND sg13g2_decap_4
Xfanout249 _4317_/S _4311_/S VPWR VGND sg13g2_buf_1
X_4266_ _5369_/D hold668/X _4224_/A _4276_/B VPWR VGND sg13g2_mux2_1
XFILLER_59_439 VPWR VGND sg13g2_decap_4
X_4197_ _5405_/D hold677/X _4338_/A _4236_/S VPWR VGND sg13g2_mux2_1
X_3217_ _3217_/Y _3217_/A _3217_/B _3217_/C VPWR VGND sg13g2_nand3_1
XFILLER_67_461 VPWR VGND sg13g2_decap_4
XFILLER_27_325 VPWR VGND sg13g2_fill_2
X_3148_ _3148_/Y _3148_/A _3148_/B VPWR VGND sg13g2_xnor2_1
XFILLER_55_612 VPWR VGND sg13g2_decap_4
XFILLER_42_328 VPWR VGND sg13g2_decap_8
X_3079_ _3086_/B _3773_/A _3750_/B VPWR VGND sg13g2_xnor2_1
XFILLER_54_155 VPWR VGND sg13g2_fill_1
XFILLER_23_531 VPWR VGND sg13g2_decap_8
XFILLER_23_575 VPWR VGND sg13g2_decap_8
XFILLER_10_203 VPWR VGND sg13g2_decap_8
XFILLER_10_214 VPWR VGND sg13g2_fill_2
XFILLER_2_457 VPWR VGND sg13g2_decap_4
XFILLER_49_21 VPWR VGND sg13g2_decap_8
XFILLER_77_225 VPWR VGND sg13g2_decap_8
XFILLER_18_336 VPWR VGND sg13g2_decap_8
XFILLER_18_347 VPWR VGND sg13g2_fill_1
XFILLER_65_97 VPWR VGND sg13g2_fill_1
XFILLER_61_626 VPWR VGND sg13g2_decap_8
XFILLER_14_531 VPWR VGND sg13g2_decap_8
XFILLER_81_52 VPWR VGND sg13g2_decap_8
XFILLER_41_383 VPWR VGND sg13g2_decap_8
XFILLER_5_240 VPWR VGND sg13g2_decap_8
XFILLER_68_203 VPWR VGND sg13g2_decap_4
X_4120_ _4123_/C _4208_/A _4112_/A _4119_/Y VPWR VGND sg13g2_o21ai_1
X_4051_ _4051_/Y _4051_/A _4051_/B _4051_/C VPWR VGND sg13g2_nor3_1
XFILLER_49_461 VPWR VGND sg13g2_fill_2
Xinput5 input5/X dmem_rdata[13] VPWR VGND sg13g2_buf_1
X_3002_ _3007_/A _5244_/Q _3620_/B VPWR VGND sg13g2_nand2_1
XFILLER_36_111 VPWR VGND sg13g2_decap_4
X_4953_ _4953_/Y _4954_/A VPWR VGND sg13g2_inv_1
XFILLER_64_497 VPWR VGND sg13g2_fill_1
XFILLER_52_637 VPWR VGND sg13g2_decap_8
XFILLER_51_169 VPWR VGND sg13g2_fill_1
X_3904_ _3905_/C _3921_/A _3895_/Y _3903_/Y VPWR VGND sg13g2_o21ai_1
XFILLER_20_501 VPWR VGND sg13g2_fill_1
X_4884_ _4889_/B _4884_/A _4884_/B VPWR VGND sg13g2_xnor2_1
X_3835_ _3837_/C _4462_/A _3826_/B _3827_/X _3828_/Y VPWR VGND sg13g2_a22oi_1
X_3766_ _3787_/B _4444_/A _3803_/A VPWR VGND sg13g2_xnor2_1
X_2717_ _2717_/X _2723_/C _2724_/A _2722_/A VPWR VGND sg13g2_and3_1
X_5436_ _5436_/X _5436_/A VPWR VGND sg13g2_buf_1
X_3697_ _3855_/B _3697_/A _3697_/B VPWR VGND sg13g2_and2_1
XFILLER_10_48 VPWR VGND sg13g2_decap_8
X_2648_ _2670_/D _4523_/A _4523_/B VPWR VGND sg13g2_nand2_1
X_5367_ _5367_/Q _5425_/CLK _5367_/D _5107_/Y VPWR VGND sg13g2_dfrbpq_1
X_2579_ _2579_/Y _2579_/A VPWR VGND sg13g2_inv_1
X_5298_ _5298_/Q _5426_/CLK _5298_/D _5038_/Y VPWR VGND sg13g2_dfrbpq_1
X_4318_ _4394_/C _4318_/A _4483_/B VPWR VGND sg13g2_nor2_1
X_4249_ _4249_/Y _4249_/A _4249_/B VPWR VGND sg13g2_nand2_1
XFILLER_28_612 VPWR VGND sg13g2_decap_8
XFILLER_27_133 VPWR VGND sg13g2_fill_2
XFILLER_67_291 VPWR VGND sg13g2_fill_2
XFILLER_55_486 VPWR VGND sg13g2_decap_4
XFILLER_70_434 VPWR VGND sg13g2_fill_1
XFILLER_42_158 VPWR VGND sg13g2_decap_8
XFILLER_11_512 VPWR VGND sg13g2_fill_2
XFILLER_11_534 VPWR VGND sg13g2_fill_1
XFILLER_19_612 VPWR VGND sg13g2_fill_2
Xfanout580 _2694_/B input48/X VPWR VGND sg13g2_buf_1
Xfanout591 _2714_/A input45/X VPWR VGND sg13g2_buf_1
XFILLER_19_634 VPWR VGND sg13g2_fill_1
XFILLER_46_442 VPWR VGND sg13g2_decap_8
XFILLER_18_188 VPWR VGND sg13g2_fill_2
XFILLER_73_294 VPWR VGND sg13g2_decap_8
XFILLER_61_445 VPWR VGND sg13g2_decap_4
XFILLER_33_158 VPWR VGND sg13g2_decap_8
X_3620_ _3626_/A _5258_/Q _3620_/B VPWR VGND sg13g2_nand2_1
X_3551_ _3973_/C _3552_/A _3552_/B VPWR VGND sg13g2_and2_1
XFILLER_6_560 VPWR VGND sg13g2_fill_1
X_3482_ _3482_/Y _5412_/Q _3555_/B1 _3464_/B _5348_/Q _3480_/Y VPWR VGND sg13g2_a221oi_1
XFILLER_6_582 VPWR VGND sg13g2_decap_8
X_5221_ _5221_/Q _5224_/CLK _5221_/D _4961_/Y VPWR VGND sg13g2_dfrbpq_1
XFILLER_69_501 VPWR VGND sg13g2_decap_4
X_5152_ _5152_/Y _5152_/A VPWR VGND sg13g2_inv_1
X_4103_ _4477_/D _4103_/A _4103_/B _4103_/C _4103_/D VPWR VGND sg13g2_nand4_1
X_5083_ _5083_/Y _5149_/A VPWR VGND sg13g2_inv_1
XFILLER_69_589 VPWR VGND sg13g2_fill_1
X_4034_ _4034_/Y _4105_/A1 _4476_/B _4033_/Y VPWR VGND sg13g2_o21ai_1
XFILLER_25_615 VPWR VGND sg13g2_decap_8
XFILLER_64_272 VPWR VGND sg13g2_decap_4
XFILLER_24_147 VPWR VGND sg13g2_fill_2
X_4936_ _4936_/Y _4942_/A VPWR VGND sg13g2_inv_1
X_4867_ _4867_/Y _4867_/A _4867_/B VPWR VGND sg13g2_nor2_1
X_3818_ _3818_/X _4041_/A _3823_/B VPWR VGND sg13g2_and2_1
X_4798_ _4827_/D _4798_/A _4799_/B VPWR VGND sg13g2_nor2_1
XFILLER_21_69 VPWR VGND sg13g2_fill_1
X_3749_ _4160_/B _3773_/A _3750_/B _4438_/A _3750_/D VPWR VGND sg13g2_and4_1
X_5419_ _5419_/Q _5421_/CLK _5419_/D _5159_/Y VPWR VGND sg13g2_dfrbpq_1
Xoutput161 dmem_wdata[8] _5444_/A VPWR VGND sg13g2_buf_1
Xoutput150 dmem_wdata[27] _5463_/A VPWR VGND sg13g2_buf_1
Xoutput172 imem_addr[17] _5210_/Q VPWR VGND sg13g2_buf_1
Xoutput183 imem_addr[27] _5220_/Q VPWR VGND sg13g2_buf_1
Xoutput194 imem_addr[8] _5201_/Q VPWR VGND sg13g2_buf_1
XFILLER_47_206 VPWR VGND sg13g2_fill_1
XFILLER_28_486 VPWR VGND sg13g2_decap_8
XFILLER_15_136 VPWR VGND sg13g2_fill_1
XFILLER_43_445 VPWR VGND sg13g2_fill_2
XFILLER_43_467 VPWR VGND sg13g2_decap_4
XFILLER_70_242 VPWR VGND sg13g2_decap_4
XFILLER_70_264 VPWR VGND sg13g2_decap_4
XFILLER_11_331 VPWR VGND sg13g2_decap_8
XFILLER_62_87 VPWR VGND sg13g2_decap_8
XFILLER_7_302 VPWR VGND sg13g2_decap_4
XFILLER_7_368 VPWR VGND sg13g2_decap_8
XFILLER_3_552 VPWR VGND sg13g2_decap_8
XFILLER_66_537 VPWR VGND sg13g2_decap_8
XFILLER_81_529 VPWR VGND sg13g2_fill_1
XFILLER_34_412 VPWR VGND sg13g2_fill_1
XFILLER_46_283 VPWR VGND sg13g2_decap_8
XFILLER_34_478 VPWR VGND sg13g2_fill_1
X_2982_ _3768_/B _3773_/A _3773_/B VPWR VGND sg13g2_nor2_1
XFILLER_61_264 VPWR VGND sg13g2_decap_8
X_4721_ _4724_/B _4746_/D _4721_/B VPWR VGND sg13g2_or2_1
X_4652_ _4654_/A _4652_/A _4652_/B VPWR VGND sg13g2_xnor2_1
Xinput30 _2587_/A dmem_rdata[7] VPWR VGND sg13g2_buf_1
X_3603_ _3606_/C _5319_/Q _3666_/B _3668_/B1 _5287_/Q VPWR VGND sg13g2_a22oi_1
Xinput63 _2575_/A imem_data[8] VPWR VGND sg13g2_buf_1
Xinput52 input52/X imem_data[27] VPWR VGND sg13g2_buf_1
Xinput41 _4394_/B imem_data[17] VPWR VGND sg13g2_buf_1
Xhold803 hold803/X _5387_/Q VPWR VGND sg13g2_dlygate4sd3_1
X_4583_ _4583_/Y _4583_/A _4583_/B VPWR VGND sg13g2_nand2_1
Xinput96 input96/X io_rdata[9] VPWR VGND sg13g2_buf_1
Xinput85 input85/X io_rdata[28] VPWR VGND sg13g2_buf_1
Xinput74 _2603_/A io_rdata[18] VPWR VGND sg13g2_buf_1
Xhold836 hold836/X _5335_/Q VPWR VGND sg13g2_dlygate4sd3_1
Xhold825 hold825/X _5289_/Q VPWR VGND sg13g2_dlygate4sd3_1
Xhold814 hold814/X _5370_/Q VPWR VGND sg13g2_dlygate4sd3_1
X_3534_ _3534_/Y _5312_/Q _3534_/A2 _3555_/B1 _5408_/Q _3533_/X VPWR VGND sg13g2_a221oi_1
Xhold869 _4649_/B _5196_/Q VPWR VGND sg13g2_dlygate4sd3_1
Xhold858 _4667_/A _5198_/Q VPWR VGND sg13g2_dlygate4sd3_1
Xhold847 hold847/X _4904_/B VPWR VGND sg13g2_dlygate4sd3_1
X_3465_ _3467_/C _5379_/Q _3687_/B _3555_/B1 _5411_/Q VPWR VGND sg13g2_a22oi_1
X_5204_ _5204_/Q _5206_/CLK _5204_/D _4944_/Y VPWR VGND sg13g2_dfrbpq_1
X_3396_ _3396_/Y _3721_/B _3721_/C VPWR VGND sg13g2_nand2_1
XFILLER_69_331 VPWR VGND sg13g2_decap_8
X_5135_ _5135_/Y _5135_/A VPWR VGND sg13g2_inv_1
X_5066_ _5066_/Y _5158_/A VPWR VGND sg13g2_inv_1
XFILLER_37_250 VPWR VGND sg13g2_fill_2
X_4017_ _4032_/A _4017_/A _4017_/B _4017_/C VPWR VGND sg13g2_nor3_1
XFILLER_25_401 VPWR VGND sg13g2_decap_8
XFILLER_25_412 VPWR VGND sg13g2_decap_8
XFILLER_25_423 VPWR VGND sg13g2_fill_1
XFILLER_65_592 VPWR VGND sg13g2_decap_8
XFILLER_25_478 VPWR VGND sg13g2_decap_8
XFILLER_40_404 VPWR VGND sg13g2_decap_8
XFILLER_52_286 VPWR VGND sg13g2_decap_8
XFILLER_80_584 VPWR VGND sg13g2_decap_8
XFILLER_52_297 VPWR VGND sg13g2_fill_1
X_4919_ _4919_/Y _5149_/A VPWR VGND sg13g2_inv_1
XFILLER_20_194 VPWR VGND sg13g2_fill_2
XFILLER_0_500 VPWR VGND sg13g2_decap_8
XFILLER_0_577 VPWR VGND sg13g2_decap_8
XFILLER_75_323 VPWR VGND sg13g2_decap_8
XFILLER_57_87 VPWR VGND sg13g2_fill_2
XFILLER_57_65 VPWR VGND sg13g2_fill_2
XFILLER_75_356 VPWR VGND sg13g2_decap_8
XFILLER_16_423 VPWR VGND sg13g2_decap_8
XFILLER_73_31 VPWR VGND sg13g2_fill_2
XFILLER_28_294 VPWR VGND sg13g2_decap_8
XFILLER_31_404 VPWR VGND sg13g2_decap_8
XFILLER_43_286 VPWR VGND sg13g2_fill_1
XFILLER_73_86 VPWR VGND sg13g2_fill_1
XFILLER_73_75 VPWR VGND sg13g2_decap_8
XFILLER_12_640 VPWR VGND sg13g2_decap_8
XFILLER_12_651 VPWR VGND sg13g2_fill_1
XFILLER_7_110 VPWR VGND sg13g2_decap_8
XFILLER_3_371 VPWR VGND sg13g2_decap_8
X_3250_ _3262_/A _3032_/X _3251_/B _3249_/Y VPWR VGND sg13g2_o21ai_1
X_3181_ _3181_/Y _3184_/B _3181_/B VPWR VGND sg13g2_xnor2_1
XFILLER_78_161 VPWR VGND sg13g2_fill_1
XFILLER_66_312 VPWR VGND sg13g2_fill_1
XFILLER_81_337 VPWR VGND sg13g2_fill_2
XFILLER_54_529 VPWR VGND sg13g2_fill_1
XFILLER_19_294 VPWR VGND sg13g2_fill_1
XFILLER_34_220 VPWR VGND sg13g2_decap_8
XFILLER_34_231 VPWR VGND sg13g2_fill_2
XFILLER_22_426 VPWR VGND sg13g2_decap_8
XFILLER_34_264 VPWR VGND sg13g2_decap_4
XFILLER_62_584 VPWR VGND sg13g2_decap_8
X_4704_ _4705_/B _4706_/B VPWR VGND sg13g2_inv_1
X_2965_ _3010_/D _3878_/A _4461_/A _2965_/C _4185_/A VPWR VGND sg13g2_nand4_1
X_2896_ _2896_/Y _2901_/A _2818_/B _2895_/Y VPWR VGND sg13g2_o21ai_1
X_4635_ _4635_/Y _4638_/A _5465_/A _4639_/C VPWR VGND sg13g2_o21ai_1
X_4566_ _4567_/A _5442_/A _5443_/A _4566_/C _5444_/A VPWR VGND sg13g2_nor4_1
Xhold622 _2558_/A _5309_/Q VPWR VGND sg13g2_dlygate4sd3_1
Xhold633 _2543_/A _5394_/Q VPWR VGND sg13g2_dlygate4sd3_1
Xhold644 _2551_/A _5366_/Q VPWR VGND sg13g2_dlygate4sd3_1
X_3517_ _3520_/B _5313_/Q _3689_/A2 _3464_/B _5345_/Q VPWR VGND sg13g2_a22oi_1
XFILLER_1_319 VPWR VGND sg13g2_fill_1
Xhold655 hold655/X _5418_/Q VPWR VGND sg13g2_dlygate4sd3_1
Xhold666 hold666/X _5184_/Q VPWR VGND sg13g2_dlygate4sd3_1
Xhold677 hold677/X _5405_/Q VPWR VGND sg13g2_dlygate4sd3_1
Xhold688 hold688/X _5235_/Q VPWR VGND sg13g2_dlygate4sd3_1
X_4497_ _5226_/D _4664_/A _4495_/Y _4496_/Y VPWR VGND sg13g2_a21oi_1
Xhold699 hold699/X _5433_/Q VPWR VGND sg13g2_dlygate4sd3_1
X_3448_ _5459_/A _3445_/Y _3446_/Y _3447_/Y VPWR VGND sg13g2_a21oi_1
X_3379_ _3721_/B _4162_/B _3417_/B VPWR VGND sg13g2_xor2_1
X_5118_ _5118_/Y _5152_/A VPWR VGND sg13g2_inv_1
XFILLER_57_356 VPWR VGND sg13g2_decap_4
X_5049_ _5049_/Y _5145_/A VPWR VGND sg13g2_inv_1
XFILLER_72_326 VPWR VGND sg13g2_decap_8
XFILLER_25_275 VPWR VGND sg13g2_fill_1
XFILLER_40_201 VPWR VGND sg13g2_decap_8
XFILLER_40_256 VPWR VGND sg13g2_decap_4
XFILLER_43_67 VPWR VGND sg13g2_fill_1
XFILLER_4_39 VPWR VGND sg13g2_fill_1
XFILLER_48_301 VPWR VGND sg13g2_fill_1
XFILLER_48_312 VPWR VGND sg13g2_fill_2
XFILLER_36_507 VPWR VGND sg13g2_decap_8
XFILLER_75_175 VPWR VGND sg13g2_decap_8
XFILLER_75_164 VPWR VGND sg13g2_fill_2
XFILLER_63_337 VPWR VGND sg13g2_fill_1
XFILLER_44_540 VPWR VGND sg13g2_decap_8
XFILLER_63_359 VPWR VGND sg13g2_fill_1
XFILLER_16_286 VPWR VGND sg13g2_decap_8
XFILLER_31_289 VPWR VGND sg13g2_fill_1
X_2750_ _2750_/Y _2750_/A _3443_/B VPWR VGND sg13g2_nor2_1
X_2681_ _2681_/Y _2999_/A _2956_/C _4520_/A VPWR VGND sg13g2_nor3_1
X_4420_ _5238_/D _4348_/A hold691/X _4424_/S VPWR VGND sg13g2_mux2_1
X_4351_ _4351_/Y _4351_/A _4351_/B VPWR VGND sg13g2_nor2_1
Xfanout409 _4572_/A _2681_/Y VPWR VGND sg13g2_buf_1
X_4282_ _4282_/Y _4427_/A _4282_/B VPWR VGND sg13g2_nand2_1
X_3302_ _4470_/C _3302_/A _3302_/B _3302_/C _3302_/D VPWR VGND sg13g2_nand4_1
X_3233_ _3234_/B _3233_/A _3233_/B _3233_/C VPWR VGND sg13g2_nor3_1
XFILLER_58_109 VPWR VGND sg13g2_decap_8
XFILLER_12_0 VPWR VGND sg13g2_decap_8
X_3164_ _3164_/Y _4436_/A _3187_/B _3236_/B1 _3148_/A VPWR VGND sg13g2_a22oi_1
XFILLER_39_389 VPWR VGND sg13g2_decap_8
X_3095_ _3096_/C _3102_/B _3095_/B VPWR VGND sg13g2_nand2_1
XFILLER_81_101 VPWR VGND sg13g2_decap_8
XFILLER_54_359 VPWR VGND sg13g2_decap_8
XFILLER_81_167 VPWR VGND sg13g2_decap_8
XFILLER_10_407 VPWR VGND sg13g2_decap_8
X_3997_ _3997_/Y _4461_/A _3997_/B VPWR VGND sg13g2_nor2_1
X_2948_ _3139_/B _3144_/A _3023_/A VPWR VGND sg13g2_xor2_1
XFILLER_13_59 VPWR VGND sg13g2_decap_8
X_4618_ _4620_/B _2895_/B _4621_/A _5460_/A _4618_/B2 VPWR VGND sg13g2_a22oi_1
X_2879_ _2879_/Y _5295_/Q _2879_/A2 _3399_/B1 _5391_/Q _2878_/X VPWR VGND sg13g2_a221oi_1
X_4549_ _4549_/Y _4697_/A _4559_/B VPWR VGND sg13g2_nand2_1
XFILLER_38_78 VPWR VGND sg13g2_decap_8
XFILLER_57_175 VPWR VGND sg13g2_fill_2
XFILLER_26_573 VPWR VGND sg13g2_fill_2
XFILLER_54_55 VPWR VGND sg13g2_fill_2
XFILLER_26_584 VPWR VGND sg13g2_decap_8
XFILLER_70_10 VPWR VGND sg13g2_fill_1
XFILLER_70_54 VPWR VGND sg13g2_fill_1
XFILLER_5_411 VPWR VGND sg13g2_decap_8
XFILLER_79_63 VPWR VGND sg13g2_fill_2
XFILLER_0_171 VPWR VGND sg13g2_decap_4
XFILLER_48_131 VPWR VGND sg13g2_decap_8
XFILLER_64_602 VPWR VGND sg13g2_fill_1
XFILLER_63_101 VPWR VGND sg13g2_fill_1
X_3920_ _3920_/Y _3920_/A _3920_/B VPWR VGND sg13g2_xnor2_1
XFILLER_32_510 VPWR VGND sg13g2_decap_4
XFILLER_44_392 VPWR VGND sg13g2_decap_8
XFILLER_32_554 VPWR VGND sg13g2_decap_8
X_3851_ _3851_/Y _3851_/A _3851_/B VPWR VGND sg13g2_nor2_1
XFILLER_32_598 VPWR VGND sg13g2_decap_4
X_3782_ _3790_/A _4444_/A _3782_/B VPWR VGND sg13g2_nor2_1
X_2802_ _2802_/Y _2561_/Y _2818_/B _3365_/B1 VPWR VGND sg13g2_o21ai_1
X_2733_ _2736_/C _5370_/Q _3003_/A2 _3363_/B1 _5274_/Q VPWR VGND sg13g2_a22oi_1
XFILLER_8_282 VPWR VGND sg13g2_fill_2
X_5452_ _5452_/X _5452_/A VPWR VGND sg13g2_buf_1
X_2664_ _2664_/X _2665_/A _2665_/B VPWR VGND sg13g2_and2_1
X_5383_ _5383_/Q clkload1/A _5383_/D _5123_/Y VPWR VGND sg13g2_dfrbpq_1
X_4403_ _5254_/D _3989_/Y hold757/X _4407_/S VPWR VGND sg13g2_mux2_1
X_2595_ _2595_/Y input5/X VPWR VGND sg13g2_inv_1
X_4334_ _5312_/D _4255_/A hold811/X _4335_/B VPWR VGND sg13g2_mux2_1
Xfanout239 _4387_/S _4360_/Y VPWR VGND sg13g2_buf_1
X_4265_ _5370_/D hold814/X _3093_/Y _4273_/S VPWR VGND sg13g2_mux2_1
X_4196_ _4338_/A _2596_/Y _3222_/B _4194_/X _4195_/Y VPWR VGND sg13g2_a22oi_1
X_3216_ _3217_/C _3216_/A _3215_/Y VPWR VGND sg13g2_nor2b_1
XFILLER_67_440 VPWR VGND sg13g2_decap_8
XFILLER_39_164 VPWR VGND sg13g2_fill_2
X_3147_ _3147_/Y _3147_/A _3147_/B _3147_/C _3147_/D VPWR VGND sg13g2_nand4_1
XFILLER_67_484 VPWR VGND sg13g2_decap_8
XFILLER_27_359 VPWR VGND sg13g2_fill_1
XFILLER_54_112 VPWR VGND sg13g2_decap_4
X_3078_ _3078_/Y _4441_/C _3773_/B VPWR VGND sg13g2_xnor2_1
XFILLER_70_605 VPWR VGND sg13g2_decap_8
XFILLER_23_510 VPWR VGND sg13g2_decap_8
XFILLER_23_554 VPWR VGND sg13g2_decap_8
XFILLER_24_69 VPWR VGND sg13g2_fill_2
XFILLER_50_373 VPWR VGND sg13g2_decap_8
XFILLER_40_35 VPWR VGND sg13g2_decap_8
XFILLER_2_414 VPWR VGND sg13g2_fill_1
XFILLER_18_304 VPWR VGND sg13g2_decap_8
XFILLER_46_602 VPWR VGND sg13g2_decap_8
XFILLER_58_473 VPWR VGND sg13g2_decap_4
XFILLER_81_31 VPWR VGND sg13g2_decap_8
XFILLER_60_159 VPWR VGND sg13g2_decap_8
XFILLER_14_587 VPWR VGND sg13g2_fill_2
XFILLER_41_362 VPWR VGND sg13g2_decap_8
XFILLER_14_80 VPWR VGND sg13g2_decap_4
XFILLER_60_8 VPWR VGND sg13g2_fill_1
XFILLER_53_7 VPWR VGND sg13g2_decap_8
XFILLER_49_440 VPWR VGND sg13g2_decap_8
X_4050_ _4051_/C _4116_/A _3574_/A _4049_/Y VPWR VGND sg13g2_o21ai_1
XFILLER_49_484 VPWR VGND sg13g2_decap_8
Xinput6 input6/X dmem_rdata[14] VPWR VGND sg13g2_buf_1
X_3001_ _3015_/A _4208_/A _3721_/A VPWR VGND sg13g2_or2_1
XFILLER_36_167 VPWR VGND sg13g2_fill_2
X_4952_ _4952_/Y _4954_/A VPWR VGND sg13g2_inv_1
XFILLER_51_148 VPWR VGND sg13g2_decap_4
X_4883_ _4901_/C _4884_/A _4884_/B VPWR VGND sg13g2_nor2_1
X_3903_ _3903_/Y _4447_/A1 _3895_/Y _3902_/Y _4043_/A _3901_/Y VPWR VGND sg13g2_a221oi_1
X_3834_ _3836_/D _3834_/A _3834_/B VPWR VGND sg13g2_nor2_1
X_3765_ _4462_/B _3765_/A _3803_/A VPWR VGND sg13g2_or2_1
X_3696_ _3697_/B _3763_/B _3701_/A VPWR VGND sg13g2_or2_1
X_2716_ _2716_/X _2716_/A _2724_/A _2716_/C VPWR VGND sg13g2_and3_1
X_5435_ _5435_/Q _5435_/CLK _5435_/D _5175_/Y VPWR VGND sg13g2_dfrbpq_1
X_2647_ _2671_/B _2656_/A _4490_/A VPWR VGND sg13g2_nor2_1
X_5366_ _5366_/Q _5426_/CLK _5366_/D _5106_/Y VPWR VGND sg13g2_dfrbpq_1
X_2578_ _2578_/Y input1/X VPWR VGND sg13g2_inv_1
XFILLER_59_204 VPWR VGND sg13g2_decap_8
X_5297_ _5297_/Q _5427_/CLK _5297_/D _5037_/Y VPWR VGND sg13g2_dfrbpq_1
X_4317_ _5327_/D _4427_/A hold721/X _4317_/S VPWR VGND sg13g2_mux2_1
XFILLER_59_237 VPWR VGND sg13g2_decap_8
X_4248_ _5381_/D hold783/X _4012_/Y _4249_/B VPWR VGND sg13g2_mux2_1
XFILLER_59_248 VPWR VGND sg13g2_decap_8
XFILLER_19_69 VPWR VGND sg13g2_decap_8
XFILLER_67_270 VPWR VGND sg13g2_decap_8
X_4179_ _5406_/D hold797/X _4178_/Y _4179_/S VPWR VGND sg13g2_mux2_1
XFILLER_55_432 VPWR VGND sg13g2_fill_1
XFILLER_35_24 VPWR VGND sg13g2_decap_4
XFILLER_55_465 VPWR VGND sg13g2_decap_8
XFILLER_70_413 VPWR VGND sg13g2_decap_8
XFILLER_70_479 VPWR VGND sg13g2_decap_8
XFILLER_70_446 VPWR VGND sg13g2_fill_1
XFILLER_23_351 VPWR VGND sg13g2_decap_8
XFILLER_23_373 VPWR VGND sg13g2_decap_8
XFILLER_7_506 VPWR VGND sg13g2_fill_2
XFILLER_11_568 VPWR VGND sg13g2_fill_2
XFILLER_51_89 VPWR VGND sg13g2_decap_4
XFILLER_78_524 VPWR VGND sg13g2_fill_2
XFILLER_76_31 VPWR VGND sg13g2_fill_2
Xfanout570 _2677_/A _2667_/A VPWR VGND sg13g2_buf_1
Xfanout581 _4615_/A1 input48/X VPWR VGND sg13g2_buf_1
Xfanout592 _3401_/A2 input45/X VPWR VGND sg13g2_buf_1
XFILLER_65_218 VPWR VGND sg13g2_decap_8
XFILLER_46_421 VPWR VGND sg13g2_decap_8
XFILLER_46_498 VPWR VGND sg13g2_decap_8
XFILLER_61_424 VPWR VGND sg13g2_decap_8
XFILLER_14_384 VPWR VGND sg13g2_decap_8
X_3550_ _3552_/B _5247_/Q _3685_/B VPWR VGND sg13g2_nand2_1
X_5220_ _5220_/Q _5224_/CLK _5220_/D _4960_/Y VPWR VGND sg13g2_dfrbpq_1
X_3481_ _3481_/Y _5316_/Q _3689_/A2 _3688_/B1 _5284_/Q _3479_/X VPWR VGND sg13g2_a221oi_1
X_5151_ _5151_/Y _5173_/A VPWR VGND sg13g2_inv_1
X_5082_ _5082_/Y _5147_/A VPWR VGND sg13g2_inv_1
X_4102_ _4103_/D _4102_/A _4102_/B VPWR VGND sg13g2_nor2_1
XFILLER_69_579 VPWR VGND sg13g2_fill_1
X_4033_ _4033_/Y _2608_/Y _2685_/B _2666_/C VPWR VGND sg13g2_a21oi_1
XFILLER_64_240 VPWR VGND sg13g2_fill_1
XFILLER_37_487 VPWR VGND sg13g2_fill_2
XFILLER_52_424 VPWR VGND sg13g2_fill_2
XFILLER_52_457 VPWR VGND sg13g2_fill_2
X_4935_ _4935_/Y _5076_/A VPWR VGND sg13g2_inv_1
XFILLER_20_310 VPWR VGND sg13g2_fill_1
XFILLER_20_321 VPWR VGND sg13g2_decap_8
X_4866_ _4885_/A _4913_/A _4873_/B VPWR VGND sg13g2_xnor2_1
XFILLER_20_343 VPWR VGND sg13g2_fill_2
X_4797_ _5211_/D _4794_/Y _4796_/Y _4789_/Y VPWR VGND sg13g2_o21ai_1
X_3817_ _3823_/B _3699_/B _3853_/B _3697_/A VPWR VGND sg13g2_o21ai_1
X_3748_ _4184_/B _4206_/A _3748_/B VPWR VGND sg13g2_nand2_1
X_3679_ _3834_/A _3679_/A _3847_/B _5465_/A VPWR VGND sg13g2_nor3_1
X_5418_ _5418_/Q clkload2/A _5418_/D _5158_/Y VPWR VGND sg13g2_dfrbpq_1
Xoutput151 dmem_wdata[28] _5464_/A VPWR VGND sg13g2_buf_1
Xoutput140 dmem_wdata[18] _5454_/A VPWR VGND sg13g2_buf_1
X_5349_ _5349_/Q clkload6/A _5349_/D _5089_/Y VPWR VGND sg13g2_dfrbpq_1
Xoutput162 dmem_wdata[9] _5445_/A VPWR VGND sg13g2_buf_1
Xoutput173 imem_addr[18] _5211_/Q VPWR VGND sg13g2_buf_1
Xoutput184 imem_addr[28] _5221_/Q VPWR VGND sg13g2_buf_1
Xoutput195 imem_addr[9] _5202_/Q VPWR VGND sg13g2_buf_1
XFILLER_28_421 VPWR VGND sg13g2_decap_4
XFILLER_47_229 VPWR VGND sg13g2_decap_8
XFILLER_16_605 VPWR VGND sg13g2_decap_8
XFILLER_28_443 VPWR VGND sg13g2_decap_4
XFILLER_28_465 VPWR VGND sg13g2_decap_8
XFILLER_43_402 VPWR VGND sg13g2_decap_8
XFILLER_70_221 VPWR VGND sg13g2_decap_8
XFILLER_62_11 VPWR VGND sg13g2_fill_1
XFILLER_62_22 VPWR VGND sg13g2_decap_4
XFILLER_11_310 VPWR VGND sg13g2_decap_8
XFILLER_7_347 VPWR VGND sg13g2_fill_2
XFILLER_7_336 VPWR VGND sg13g2_decap_8
XFILLER_3_597 VPWR VGND sg13g2_fill_1
XFILLER_38_207 VPWR VGND sg13g2_decap_8
XFILLER_66_516 VPWR VGND sg13g2_decap_8
XFILLER_16_7 VPWR VGND sg13g2_decap_4
XFILLER_19_421 VPWR VGND sg13g2_fill_2
XFILLER_46_251 VPWR VGND sg13g2_fill_1
XFILLER_19_476 VPWR VGND sg13g2_decap_4
XFILLER_19_487 VPWR VGND sg13g2_decap_8
XFILLER_46_262 VPWR VGND sg13g2_decap_8
XFILLER_74_593 VPWR VGND sg13g2_decap_8
X_2981_ _3773_/B _4439_/A _4439_/C _3205_/B _2981_/D VPWR VGND sg13g2_nand4_1
X_4720_ _4720_/Y _5203_/Q _4710_/B hold888/X VPWR VGND sg13g2_a21oi_1
X_4651_ _4651_/Y _4652_/A _4652_/B VPWR VGND sg13g2_nand2_1
Xinput31 _2588_/A dmem_rdata[8] VPWR VGND sg13g2_buf_1
Xinput20 _3889_/A dmem_rdata[27] VPWR VGND sg13g2_buf_1
X_3602_ _3606_/B _5255_/Q _3620_/B _3682_/B1 _5415_/Q VPWR VGND sg13g2_a22oi_1
Xinput64 _4706_/A imem_data[9] VPWR VGND sg13g2_buf_1
Xinput53 _2667_/B imem_data[28] VPWR VGND sg13g2_buf_1
Xinput42 _4360_/A imem_data[18] VPWR VGND sg13g2_buf_1
X_4582_ _4583_/B _4879_/A _4621_/A _4619_/B _4581_/Y VPWR VGND sg13g2_a22oi_1
Xinput97 input97/X rst VPWR VGND sg13g2_buf_1
Xinput86 _3838_/A io_rdata[29] VPWR VGND sg13g2_buf_1
Xinput75 input75/X io_rdata[19] VPWR VGND sg13g2_buf_1
Xhold837 hold837/X _5431_/Q VPWR VGND sg13g2_dlygate4sd3_1
Xhold826 hold826/X _5322_/Q VPWR VGND sg13g2_dlygate4sd3_1
Xhold815 hold815/X _5277_/Q VPWR VGND sg13g2_dlygate4sd3_1
Xhold804 hold804/X _5287_/Q VPWR VGND sg13g2_dlygate4sd3_1
X_3533_ _3533_/X _5180_/Q _3553_/B VPWR VGND sg13g2_and2_1
Xhold859 _4668_/B _4670_/B VPWR VGND sg13g2_dlygate4sd3_1
Xhold848 _4876_/B _5220_/Q VPWR VGND sg13g2_dlygate4sd3_1
X_3464_ _3467_/B _5347_/Q _3464_/B VPWR VGND sg13g2_nand2_1
X_5203_ _5203_/Q _5206_/CLK _5203_/D _4943_/Y VPWR VGND sg13g2_dfrbpq_1
X_5134_ _5134_/Y _5134_/A VPWR VGND sg13g2_inv_1
X_3395_ _3721_/C _4160_/A _3418_/B VPWR VGND sg13g2_xnor2_1
XFILLER_69_365 VPWR VGND sg13g2_decap_8
X_5065_ _5065_/Y _5161_/A VPWR VGND sg13g2_inv_1
XFILLER_57_538 VPWR VGND sg13g2_fill_2
X_4016_ _4017_/C _4088_/B _4016_/B VPWR VGND sg13g2_nand2_1
XFILLER_72_519 VPWR VGND sg13g2_decap_8
XFILLER_37_273 VPWR VGND sg13g2_fill_2
XFILLER_65_571 VPWR VGND sg13g2_decap_8
XFILLER_25_457 VPWR VGND sg13g2_decap_8
XFILLER_52_265 VPWR VGND sg13g2_decap_8
XFILLER_80_563 VPWR VGND sg13g2_decap_8
XFILLER_40_449 VPWR VGND sg13g2_decap_8
X_4918_ _4918_/Y _5147_/A VPWR VGND sg13g2_inv_1
X_4849_ _4852_/A _4849_/A _4849_/B VPWR VGND sg13g2_nor2_1
XFILLER_0_556 VPWR VGND sg13g2_decap_8
XFILLER_75_379 VPWR VGND sg13g2_fill_1
XFILLER_16_402 VPWR VGND sg13g2_fill_2
XFILLER_43_210 VPWR VGND sg13g2_decap_8
XFILLER_16_457 VPWR VGND sg13g2_decap_8
XFILLER_43_232 VPWR VGND sg13g2_decap_4
XFILLER_73_54 VPWR VGND sg13g2_decap_8
XFILLER_24_490 VPWR VGND sg13g2_fill_2
Xclkbuf_leaf_23_clk clkload4/A clkbuf_2_0__f_clk/X VPWR VGND sg13g2_buf_8
XFILLER_7_177 VPWR VGND sg13g2_fill_2
XFILLER_79_641 VPWR VGND sg13g2_fill_2
X_3180_ _5430_/D hold676/X _4348_/A _4517_/S VPWR VGND sg13g2_mux2_1
XFILLER_78_140 VPWR VGND sg13g2_decap_4
XFILLER_66_324 VPWR VGND sg13g2_decap_8
XFILLER_66_379 VPWR VGND sg13g2_fill_2
XFILLER_34_243 VPWR VGND sg13g2_decap_8
XFILLER_62_552 VPWR VGND sg13g2_decap_4
XFILLER_22_405 VPWR VGND sg13g2_fill_2
XFILLER_34_298 VPWR VGND sg13g2_decap_8
X_2964_ _3010_/C _3921_/A _2965_/C _2964_/C VPWR VGND sg13g2_nand3_1
Xclkbuf_leaf_14_clk _5206_/CLK clkbuf_2_3__f_clk/X VPWR VGND sg13g2_buf_8
X_4703_ _4706_/B _4719_/A _4719_/D VPWR VGND sg13g2_xnor2_1
XFILLER_30_471 VPWR VGND sg13g2_decap_8
XFILLER_30_482 VPWR VGND sg13g2_fill_2
X_2895_ _2895_/Y _5427_/Q _2895_/B _2895_/C _2895_/D VPWR VGND sg13g2_nand4_1
X_4634_ _4634_/Y _4633_/B _4632_/Y _4639_/C VPWR VGND sg13g2_o21ai_1
X_4565_ _4565_/Y _4565_/A _4565_/B VPWR VGND sg13g2_xnor2_1
Xhold623 _2559_/A _5303_/Q VPWR VGND sg13g2_dlygate4sd3_1
Xhold634 _2554_/A _5361_/Q VPWR VGND sg13g2_dlygate4sd3_1
Xhold645 _2555_/A _5360_/Q VPWR VGND sg13g2_dlygate4sd3_1
X_3516_ _3520_/A _5249_/Q _3677_/B VPWR VGND sg13g2_nand2_1
Xhold656 hold656/X _5422_/Q VPWR VGND sg13g2_dlygate4sd3_1
Xhold667 hold667/X _5410_/Q VPWR VGND sg13g2_dlygate4sd3_1
Xhold678 hold678/X _5259_/Q VPWR VGND sg13g2_dlygate4sd3_1
X_4496_ _4496_/Y _4496_/A _4664_/A VPWR VGND sg13g2_nor2_1
Xhold689 hold689/X _5346_/Q VPWR VGND sg13g2_dlygate4sd3_1
X_3447_ _3447_/Y _5254_/Q _2724_/A _3692_/A2 VPWR VGND sg13g2_a21oi_1
X_3378_ _4152_/A _3726_/A _3378_/B VPWR VGND sg13g2_and2_1
X_5117_ _5117_/Y _5134_/A VPWR VGND sg13g2_inv_1
XFILLER_27_25 VPWR VGND sg13g2_decap_4
X_5048_ _5048_/Y _5112_/A VPWR VGND sg13g2_inv_1
XFILLER_72_338 VPWR VGND sg13g2_fill_1
XFILLER_53_585 VPWR VGND sg13g2_decap_8
XFILLER_25_287 VPWR VGND sg13g2_decap_8
XFILLER_43_46 VPWR VGND sg13g2_decap_8
XFILLER_5_648 VPWR VGND sg13g2_decap_4
XFILLER_0_320 VPWR VGND sg13g2_fill_2
XFILLER_68_32 VPWR VGND sg13g2_decap_8
XFILLER_76_611 VPWR VGND sg13g2_fill_1
XFILLER_0_375 VPWR VGND sg13g2_decap_8
XFILLER_68_98 VPWR VGND sg13g2_decap_8
XFILLER_48_357 VPWR VGND sg13g2_decap_8
XFILLER_29_571 VPWR VGND sg13g2_decap_8
XFILLER_16_232 VPWR VGND sg13g2_decap_4
XFILLER_44_596 VPWR VGND sg13g2_decap_8
XFILLER_12_471 VPWR VGND sg13g2_decap_4
X_2680_ _2680_/Y _3887_/B VPWR VGND sg13g2_inv_1
XFILLER_8_486 VPWR VGND sg13g2_decap_8
X_4350_ _5301_/D _3198_/Y hold704/X _4350_/S VPWR VGND sg13g2_mux2_1
X_3301_ _3302_/D _4139_/A1 _3289_/A _3300_/Y VPWR VGND sg13g2_a21oi_1
X_4281_ _5360_/D _2555_/Y _4280_/B _4280_/Y VPWR VGND sg13g2_o21ai_1
Xclkbuf_leaf_3_clk _5414_/CLK clkbuf_leaf_3_clk/A VPWR VGND sg13g2_buf_8
X_3232_ _3233_/C _4159_/A _3253_/A _3232_/C VPWR VGND sg13g2_nor3_1
XFILLER_67_600 VPWR VGND sg13g2_fill_1
X_3163_ _3163_/Y _4435_/A _3206_/B _4159_/A VPWR VGND sg13g2_a21oi_1
XFILLER_39_368 VPWR VGND sg13g2_decap_8
XFILLER_66_154 VPWR VGND sg13g2_decap_4
X_3094_ _5434_/D hold792/X _3093_/Y _4517_/S VPWR VGND sg13g2_mux2_1
XFILLER_54_338 VPWR VGND sg13g2_decap_8
XFILLER_35_552 VPWR VGND sg13g2_decap_8
XFILLER_22_213 VPWR VGND sg13g2_fill_1
XFILLER_50_511 VPWR VGND sg13g2_fill_1
XFILLER_62_393 VPWR VGND sg13g2_decap_8
XFILLER_50_544 VPWR VGND sg13g2_decap_8
X_3996_ _3997_/B _3996_/A _3996_/B VPWR VGND sg13g2_nand2_1
XFILLER_50_588 VPWR VGND sg13g2_decap_8
X_2947_ _2951_/B _3144_/A _3023_/A VPWR VGND sg13g2_and2_1
X_4617_ _4621_/C _5460_/A _4623_/C _4623_/D VPWR VGND sg13g2_nor3_1
X_2878_ _2878_/X _5423_/Q _3397_/B VPWR VGND sg13g2_and2_1
X_4548_ _4548_/Y _4548_/A _4548_/B VPWR VGND sg13g2_xnor2_1
X_4479_ _4480_/C _4479_/A _4479_/B _4479_/C _4479_/D VPWR VGND sg13g2_nor4_1
XFILLER_38_24 VPWR VGND sg13g2_decap_4
XFILLER_58_611 VPWR VGND sg13g2_fill_1
XFILLER_73_603 VPWR VGND sg13g2_fill_1
XFILLER_58_644 VPWR VGND sg13g2_decap_8
XFILLER_57_143 VPWR VGND sg13g2_fill_2
XFILLER_18_519 VPWR VGND sg13g2_decap_8
XFILLER_73_647 VPWR VGND sg13g2_fill_1
XFILLER_54_23 VPWR VGND sg13g2_decap_4
XFILLER_72_168 VPWR VGND sg13g2_decap_8
XFILLER_60_308 VPWR VGND sg13g2_fill_2
XFILLER_41_511 VPWR VGND sg13g2_decap_8
XFILLER_70_77 VPWR VGND sg13g2_fill_2
XFILLER_70_66 VPWR VGND sg13g2_decap_8
XFILLER_5_445 VPWR VGND sg13g2_decap_4
XFILLER_0_150 VPWR VGND sg13g2_decap_8
XFILLER_0_194 VPWR VGND sg13g2_decap_8
XFILLER_36_327 VPWR VGND sg13g2_fill_1
XFILLER_63_124 VPWR VGND sg13g2_decap_4
XFILLER_51_319 VPWR VGND sg13g2_fill_2
XFILLER_63_157 VPWR VGND sg13g2_decap_8
XFILLER_17_585 VPWR VGND sg13g2_fill_1
XFILLER_44_371 VPWR VGND sg13g2_decap_8
XFILLER_32_544 VPWR VGND sg13g2_decap_4
X_3850_ _3851_/B _4162_/A _3879_/B _3849_/Y VPWR VGND sg13g2_o21ai_1
X_3781_ _3782_/B _3764_/A _3785_/C _4043_/A VPWR VGND sg13g2_o21ai_1
X_2801_ _2801_/Y _5364_/Q _3003_/A2 _3361_/B _5396_/Q _2800_/X VPWR VGND sg13g2_a221oi_1
X_2732_ _2736_/B _5306_/Q _2920_/A2 _3361_/B _5402_/Q VPWR VGND sg13g2_a22oi_1
X_5451_ _5451_/X _5451_/A VPWR VGND sg13g2_buf_1
X_2663_ _2665_/B _3000_/A _4521_/C _3000_/C VPWR VGND sg13g2_nand3_1
X_5382_ _5382_/Q _5421_/CLK _5382_/D _5122_/Y VPWR VGND sg13g2_dfrbpq_1
X_4402_ _5255_/D _3953_/Y hold799/X _4409_/S VPWR VGND sg13g2_mux2_1
X_2594_ _2594_/Y _2594_/A VPWR VGND sg13g2_inv_1
X_4333_ _5313_/D _4253_/A hold718/X _4359_/S VPWR VGND sg13g2_mux2_1
X_4264_ _5371_/D _3068_/Y _4273_/S _4263_/Y VPWR VGND sg13g2_a21oi_1
XFILLER_59_419 VPWR VGND sg13g2_fill_1
X_3215_ _3215_/Y _4435_/B _3187_/B _3236_/B1 _4435_/A _3213_/Y VPWR VGND sg13g2_a221oi_1
XFILLER_39_132 VPWR VGND sg13g2_fill_2
X_4195_ _4195_/Y _4749_/A _4195_/A2 _3222_/B VPWR VGND sg13g2_a21oi_1
XFILLER_79_290 VPWR VGND sg13g2_fill_2
XFILLER_27_305 VPWR VGND sg13g2_fill_2
X_3146_ _3147_/D _4188_/A1 _2951_/B _3139_/B _3102_/A _3145_/Y VPWR VGND sg13g2_a221oi_1
XFILLER_55_625 VPWR VGND sg13g2_fill_1
XFILLER_27_327 VPWR VGND sg13g2_fill_1
X_3077_ _3077_/Y _4111_/A _3074_/Y _3076_/Y VPWR VGND sg13g2_o21ai_1
XFILLER_54_135 VPWR VGND sg13g2_fill_2
XFILLER_54_124 VPWR VGND sg13g2_fill_2
XFILLER_70_617 VPWR VGND sg13g2_fill_2
XFILLER_35_371 VPWR VGND sg13g2_decap_8
X_3979_ _4041_/B _4040_/B _4040_/C _4048_/B VPWR VGND sg13g2_a21o_1
XFILLER_49_56 VPWR VGND sg13g2_fill_1
XFILLER_49_89 VPWR VGND sg13g2_decap_8
XFILLER_46_625 VPWR VGND sg13g2_fill_2
XFILLER_26_360 VPWR VGND sg13g2_decap_8
XFILLER_26_371 VPWR VGND sg13g2_fill_1
XFILLER_14_566 VPWR VGND sg13g2_decap_8
XFILLER_81_21 VPWR VGND sg13g2_decap_4
XFILLER_60_138 VPWR VGND sg13g2_decap_8
XFILLER_14_577 VPWR VGND sg13g2_fill_1
XFILLER_81_87 VPWR VGND sg13g2_decap_8
XFILLER_5_220 VPWR VGND sg13g2_decap_8
XFILLER_68_227 VPWR VGND sg13g2_fill_2
XFILLER_49_463 VPWR VGND sg13g2_fill_1
Xinput7 input7/X dmem_rdata[15] VPWR VGND sg13g2_buf_1
X_3000_ _4162_/A _3000_/A _3000_/B _3000_/C VPWR VGND sg13g2_nand3_1
XFILLER_76_282 VPWR VGND sg13g2_decap_8
XFILLER_64_422 VPWR VGND sg13g2_decap_8
X_4951_ _4951_/Y _4951_/A VPWR VGND sg13g2_inv_1
XFILLER_64_488 VPWR VGND sg13g2_decap_8
X_4882_ _5220_/D _4878_/A _4881_/Y _4878_/Y VPWR VGND sg13g2_a21oi_1
X_3902_ _3902_/Y _4445_/B _3902_/B VPWR VGND sg13g2_xnor2_1
XFILLER_20_514 VPWR VGND sg13g2_fill_2
X_3833_ _3834_/B _3938_/A _4449_/C _3832_/Y VPWR VGND sg13g2_a21oi_1
XFILLER_20_547 VPWR VGND sg13g2_decap_4
X_3764_ _3803_/A _3764_/A _4445_/C _3825_/B VPWR VGND sg13g2_nand3_1
X_3695_ _3697_/A _3763_/B _3701_/A VPWR VGND sg13g2_nand2_1
X_2715_ _2727_/B _5243_/Q _3677_/B VPWR VGND sg13g2_nand2_1
X_5434_ _5434_/Q _5434_/CLK _5434_/D _5174_/Y VPWR VGND sg13g2_dfrbpq_1
X_2646_ _2646_/Y _2677_/A _4521_/A _3000_/B _2673_/B VPWR VGND sg13g2_nand4_1
X_5365_ _5365_/Q _5435_/CLK _5365_/D _5105_/Y VPWR VGND sg13g2_dfrbpq_1
X_2577_ _2577_/Y _2577_/A VPWR VGND sg13g2_inv_1
X_5296_ _5296_/Q _5424_/CLK _5296_/D _5036_/Y VPWR VGND sg13g2_dfrbpq_1
X_4316_ _5328_/D _4280_/A hold749/X _4317_/S VPWR VGND sg13g2_mux2_1
X_4247_ _5382_/D hold785/X _3989_/Y _4247_/S VPWR VGND sg13g2_mux2_1
XFILLER_19_48 VPWR VGND sg13g2_fill_2
X_4178_ _4178_/Y _2598_/Y _4178_/A2 _4176_/Y _4177_/Y VPWR VGND sg13g2_a22oi_1
XFILLER_74_219 VPWR VGND sg13g2_decap_8
XFILLER_74_208 VPWR VGND sg13g2_fill_2
XFILLER_67_260 VPWR VGND sg13g2_fill_1
XFILLER_67_293 VPWR VGND sg13g2_fill_1
XFILLER_15_308 VPWR VGND sg13g2_decap_4
X_3129_ _3129_/Y _3129_/A _4131_/A VPWR VGND sg13g2_nor2_1
XFILLER_27_179 VPWR VGND sg13g2_decap_8
XFILLER_35_58 VPWR VGND sg13g2_decap_8
XFILLER_42_105 VPWR VGND sg13g2_decap_8
XFILLER_43_628 VPWR VGND sg13g2_decap_8
XFILLER_35_190 VPWR VGND sg13g2_decap_4
XFILLER_42_138 VPWR VGND sg13g2_decap_4
XFILLER_23_396 VPWR VGND sg13g2_fill_2
XFILLER_51_68 VPWR VGND sg13g2_decap_8
XFILLER_78_536 VPWR VGND sg13g2_fill_1
Xfanout560 _5174_/A fanout564/X VPWR VGND sg13g2_buf_1
XFILLER_46_400 VPWR VGND sg13g2_decap_8
Xfanout571 _4521_/A _2667_/B VPWR VGND sg13g2_buf_1
Xfanout582 _2895_/C _3365_/A2 VPWR VGND sg13g2_buf_1
XFILLER_18_102 VPWR VGND sg13g2_decap_8
XFILLER_19_625 VPWR VGND sg13g2_decap_8
XFILLER_46_477 VPWR VGND sg13g2_decap_8
XFILLER_73_274 VPWR VGND sg13g2_decap_4
XFILLER_26_190 VPWR VGND sg13g2_decap_8
XFILLER_41_160 VPWR VGND sg13g2_decap_4
X_3480_ _3480_/Y _2544_/Y _3386_/B _3692_/A2 VPWR VGND sg13g2_o21ai_1
XFILLER_6_551 VPWR VGND sg13g2_decap_8
X_5150_ _5150_/Y _5150_/A VPWR VGND sg13g2_inv_1
XFILLER_69_525 VPWR VGND sg13g2_fill_2
X_5081_ _5081_/Y _5145_/A VPWR VGND sg13g2_inv_1
X_4101_ _4103_/C _4447_/A1 _4100_/B _4099_/Y VPWR VGND sg13g2_a21oi_1
XFILLER_69_558 VPWR VGND sg13g2_decap_8
X_4032_ _4476_/B _4032_/A _4032_/B VPWR VGND sg13g2_or2_1
XFILLER_52_403 VPWR VGND sg13g2_decap_8
XFILLER_24_149 VPWR VGND sg13g2_fill_1
X_4934_ _4934_/Y _5158_/A VPWR VGND sg13g2_inv_1
X_4865_ _4880_/A _4913_/A _4873_/B VPWR VGND sg13g2_and2_1
XFILLER_60_480 VPWR VGND sg13g2_decap_8
X_4796_ _4796_/Y _4796_/A _4796_/B VPWR VGND sg13g2_nand2_1
X_3816_ _5421_/D hold708/X _3815_/Y _4013_/S VPWR VGND sg13g2_mux2_1
XFILLER_20_377 VPWR VGND sg13g2_decap_8
X_3747_ _3750_/D _4441_/B _4206_/B VPWR VGND sg13g2_nor2_1
XFILLER_21_38 VPWR VGND sg13g2_decap_4
X_3678_ _4639_/B _3678_/A _3678_/B _3678_/C _3678_/D VPWR VGND sg13g2_nand4_1
X_5417_ _5417_/Q clkload5/A _5417_/D _5157_/Y VPWR VGND sg13g2_dfrbpq_1
Xoutput152 dmem_wdata[29] _5465_/A VPWR VGND sg13g2_buf_1
Xoutput141 dmem_wdata[19] _5455_/A VPWR VGND sg13g2_buf_1
Xoutput130 dmem_rd output130/A VPWR VGND sg13g2_buf_1
X_2629_ _4798_/A _5212_/Q VPWR VGND sg13g2_inv_1
X_5348_ _5348_/Q clkload6/A _5348_/D _5088_/Y VPWR VGND sg13g2_dfrbpq_1
Xoutput163 dmem_wr _4522_/Y VPWR VGND sg13g2_buf_1
Xoutput174 imem_addr[19] _5212_/Q VPWR VGND sg13g2_buf_1
Xoutput185 imem_addr[29] _5222_/Q VPWR VGND sg13g2_buf_1
Xoutput196 io_rd _3838_/B VPWR VGND sg13g2_buf_1
X_5279_ _5279_/Q _5424_/CLK _5279_/D _5019_/Y VPWR VGND sg13g2_dfrbpq_1
XFILLER_75_528 VPWR VGND sg13g2_decap_8
XFILLER_75_506 VPWR VGND sg13g2_fill_1
XFILLER_15_116 VPWR VGND sg13g2_decap_4
XFILLER_55_274 VPWR VGND sg13g2_fill_1
XFILLER_43_447 VPWR VGND sg13g2_fill_1
XFILLER_51_491 VPWR VGND sg13g2_decap_8
XFILLER_11_366 VPWR VGND sg13g2_decap_8
XFILLER_11_82 VPWR VGND sg13g2_fill_2
XFILLER_2_0 VPWR VGND sg13g2_decap_8
XFILLER_3_576 VPWR VGND sg13g2_decap_8
XFILLER_19_400 VPWR VGND sg13g2_decap_8
XFILLER_19_433 VPWR VGND sg13g2_decap_8
Xfanout390 _3120_/A _4433_/B VPWR VGND sg13g2_buf_1
XFILLER_46_241 VPWR VGND sg13g2_fill_1
XFILLER_34_425 VPWR VGND sg13g2_fill_2
XFILLER_61_211 VPWR VGND sg13g2_decap_8
XFILLER_34_458 VPWR VGND sg13g2_decap_8
XFILLER_21_108 VPWR VGND sg13g2_decap_8
XFILLER_22_609 VPWR VGND sg13g2_fill_2
XFILLER_34_469 VPWR VGND sg13g2_fill_1
X_2980_ _3117_/B _4439_/C _3205_/B _2981_/D VPWR VGND sg13g2_and3_1
XFILLER_42_491 VPWR VGND sg13g2_decap_8
XFILLER_61_299 VPWR VGND sg13g2_decap_8
X_4650_ _4650_/Y _4664_/A _4652_/B VPWR VGND sg13g2_nor2_1
Xinput21 _2619_/A dmem_rdata[28] VPWR VGND sg13g2_buf_1
Xinput10 _2604_/A dmem_rdata[18] VPWR VGND sg13g2_buf_1
X_3601_ _3606_/A _5187_/Q _3637_/B VPWR VGND sg13g2_nand2_1
Xinput54 _2667_/A imem_data[29] VPWR VGND sg13g2_buf_1
Xinput43 _4318_/A imem_data[19] VPWR VGND sg13g2_buf_1
Xinput32 _2589_/A dmem_rdata[9] VPWR VGND sg13g2_buf_1
X_4581_ _4581_/Y _5451_/A _4581_/B VPWR VGND sg13g2_xnor2_1
Xinput87 _2581_/A io_rdata[2] VPWR VGND sg13g2_buf_1
Xinput76 _2579_/A io_rdata[1] VPWR VGND sg13g2_buf_1
Xinput65 _2577_/A io_rdata[0] VPWR VGND sg13g2_buf_1
Xhold827 hold827/X _5428_/Q VPWR VGND sg13g2_dlygate4sd3_1
Xhold816 hold816/X _5276_/Q VPWR VGND sg13g2_dlygate4sd3_1
Xhold805 hold805/X _5310_/Q VPWR VGND sg13g2_dlygate4sd3_1
X_3532_ _3542_/B _4360_/B _3559_/S VPWR VGND sg13g2_nor2_1
Xhold849 _4877_/A _4875_/Y VPWR VGND sg13g2_dlygate4sd3_1
Xhold838 hold838/X _5333_/Q VPWR VGND sg13g2_dlygate4sd3_1
X_3463_ _3467_/A _5315_/Q _3689_/A2 _3688_/B1 _5283_/Q VPWR VGND sg13g2_a22oi_1
X_5202_ _5202_/Q _5206_/CLK _5202_/D _4942_/Y VPWR VGND sg13g2_dfrbpq_1
XFILLER_69_311 VPWR VGND sg13g2_fill_2
XFILLER_35_0 VPWR VGND sg13g2_decap_8
X_5133_ _5133_/Y _5174_/A VPWR VGND sg13g2_inv_1
X_3394_ _3726_/B _4160_/A _3418_/B VPWR VGND sg13g2_nor2_1
XFILLER_57_517 VPWR VGND sg13g2_decap_8
X_5064_ _5064_/Y _5125_/A VPWR VGND sg13g2_inv_1
X_4015_ _4017_/B _4048_/B _3957_/X _4014_/X VPWR VGND sg13g2_a21oi_1
XFILLER_65_550 VPWR VGND sg13g2_decap_8
XFILLER_16_38 VPWR VGND sg13g2_fill_2
XFILLER_25_436 VPWR VGND sg13g2_decap_8
XFILLER_52_244 VPWR VGND sg13g2_decap_8
XFILLER_13_609 VPWR VGND sg13g2_fill_2
XFILLER_21_620 VPWR VGND sg13g2_fill_2
X_4917_ _4917_/Y _5145_/A VPWR VGND sg13g2_inv_1
XFILLER_20_141 VPWR VGND sg13g2_decap_4
X_4848_ _4849_/B _4848_/A _4848_/B _4848_/C _4848_/D VPWR VGND sg13g2_nand4_1
XFILLER_32_59 VPWR VGND sg13g2_decap_8
XFILLER_4_307 VPWR VGND sg13g2_fill_2
X_4779_ _4788_/B _5209_/Q _5210_/Q _4787_/D VPWR VGND sg13g2_nand3_1
XFILLER_79_108 VPWR VGND sg13g2_decap_4
XFILLER_0_535 VPWR VGND sg13g2_decap_8
XFILLER_48_506 VPWR VGND sg13g2_fill_1
XFILLER_57_89 VPWR VGND sg13g2_fill_1
XFILLER_73_11 VPWR VGND sg13g2_fill_2
XFILLER_56_572 VPWR VGND sg13g2_fill_1
XFILLER_73_33 VPWR VGND sg13g2_fill_1
XFILLER_71_520 VPWR VGND sg13g2_decap_8
XFILLER_43_266 VPWR VGND sg13g2_decap_4
XFILLER_8_613 VPWR VGND sg13g2_decap_8
XFILLER_11_163 VPWR VGND sg13g2_decap_8
XFILLER_39_539 VPWR VGND sg13g2_decap_8
XFILLER_78_185 VPWR VGND sg13g2_fill_1
XFILLER_19_263 VPWR VGND sg13g2_decap_8
XFILLER_19_274 VPWR VGND sg13g2_fill_2
XFILLER_47_583 VPWR VGND sg13g2_decap_8
XFILLER_74_380 VPWR VGND sg13g2_fill_1
XFILLER_62_520 VPWR VGND sg13g2_decap_8
XFILLER_34_277 VPWR VGND sg13g2_decap_8
X_2963_ _2964_/C _4068_/A _2963_/B VPWR VGND sg13g2_nor2_1
X_4702_ _4710_/B _4719_/A _4719_/D VPWR VGND sg13g2_nor2_1
XFILLER_30_450 VPWR VGND sg13g2_decap_8
X_2894_ _2894_/Y _2894_/A _2894_/B VPWR VGND sg13g2_nor2_1
X_4633_ _4639_/C _5464_/A _4633_/B VPWR VGND sg13g2_nand2b_2
XFILLER_8_61 VPWR VGND sg13g2_decap_4
X_4564_ _4565_/B _5447_/A _5446_/A _4564_/C VPWR VGND sg13g2_nor3_1
Xhold613 _4468_/A _5228_/Q VPWR VGND sg13g2_dlygate4sd3_1
Xhold624 _2562_/A _5299_/Q VPWR VGND sg13g2_dlygate4sd3_1
Xhold635 _2550_/A _5367_/Q VPWR VGND sg13g2_dlygate4sd3_1
X_3515_ _3973_/A _4095_/B VPWR VGND sg13g2_inv_1
Xhold646 hold646/X _5424_/Q VPWR VGND sg13g2_dlygate4sd3_1
Xhold657 hold657/X _5240_/Q VPWR VGND sg13g2_dlygate4sd3_1
Xhold668 hold668/X _5369_/Q VPWR VGND sg13g2_dlygate4sd3_1
Xhold679 hold679/X _5283_/Q VPWR VGND sg13g2_dlygate4sd3_1
X_4495_ _4495_/Y _4495_/A _4495_/B VPWR VGND sg13g2_xnor2_1
X_3446_ _3446_/Y _5382_/Q _3676_/A2 _3676_/B1 _5350_/Q _3444_/X VPWR VGND sg13g2_a221oi_1
X_3377_ _3378_/B _3417_/B _4162_/B VPWR VGND sg13g2_nand2b_1
X_5116_ _5116_/Y _5147_/A VPWR VGND sg13g2_inv_1
X_5047_ _5047_/Y _5145_/A VPWR VGND sg13g2_inv_1
XFILLER_38_583 VPWR VGND sg13g2_decap_8
XFILLER_72_306 VPWR VGND sg13g2_fill_2
XFILLER_53_564 VPWR VGND sg13g2_decap_8
XFILLER_13_417 VPWR VGND sg13g2_decap_4
XFILLER_13_428 VPWR VGND sg13g2_fill_2
XFILLER_21_450 VPWR VGND sg13g2_fill_1
XFILLER_5_627 VPWR VGND sg13g2_decap_8
XFILLER_4_159 VPWR VGND sg13g2_decap_8
XFILLER_0_343 VPWR VGND sg13g2_fill_2
XFILLER_68_77 VPWR VGND sg13g2_decap_8
XFILLER_48_314 VPWR VGND sg13g2_fill_1
XFILLER_48_336 VPWR VGND sg13g2_decap_8
XFILLER_63_306 VPWR VGND sg13g2_decap_8
XFILLER_16_211 VPWR VGND sg13g2_decap_8
XFILLER_17_81 VPWR VGND sg13g2_decap_8
XFILLER_44_575 VPWR VGND sg13g2_decap_8
XFILLER_31_247 VPWR VGND sg13g2_fill_2
XFILLER_12_483 VPWR VGND sg13g2_decap_8
XFILLER_8_432 VPWR VGND sg13g2_decap_4
XFILLER_76_7 VPWR VGND sg13g2_decap_4
XFILLER_8_465 VPWR VGND sg13g2_decap_8
X_3300_ _3300_/Y _4210_/A1 _2869_/A _3299_/Y VPWR VGND sg13g2_o21ai_1
XFILLER_3_170 VPWR VGND sg13g2_fill_1
X_4280_ _4280_/Y _4280_/A _4280_/B VPWR VGND sg13g2_nand2_1
X_3231_ _3234_/A _4457_/B _3231_/B _3231_/C VPWR VGND sg13g2_and3_1
X_3162_ _3162_/Y _4436_/A _3162_/B VPWR VGND sg13g2_xnor2_1
XFILLER_39_347 VPWR VGND sg13g2_decap_8
X_3093_ _3093_/Y _2593_/Y _3222_/B _3091_/Y _3092_/Y VPWR VGND sg13g2_a22oi_1
XFILLER_35_520 VPWR VGND sg13g2_fill_2
XFILLER_81_147 VPWR VGND sg13g2_fill_2
XFILLER_66_188 VPWR VGND sg13g2_decap_8
XFILLER_50_523 VPWR VGND sg13g2_decap_8
XFILLER_62_361 VPWR VGND sg13g2_decap_8
X_3995_ _3996_/B _4448_/C _4018_/B _4450_/A VPWR VGND sg13g2_o21ai_1
X_2946_ _3023_/A _2575_/A _5444_/A _3392_/S VPWR VGND sg13g2_mux2_1
X_2877_ _2887_/A _4524_/A _3704_/A VPWR VGND sg13g2_and2_1
X_4616_ _4616_/Y _4623_/C _4614_/Y _4615_/Y VPWR VGND sg13g2_o21ai_1
X_4547_ _4551_/B _4548_/A _4548_/B VPWR VGND sg13g2_nor2_1
X_4478_ _4480_/B _4478_/A _4478_/B _4478_/C _4478_/D VPWR VGND sg13g2_and4_1
X_3429_ _3432_/B _5413_/Q _3689_/B1 _3676_/B1 _5349_/Q VPWR VGND sg13g2_a22oi_1
XFILLER_58_623 VPWR VGND sg13g2_decap_8
XFILLER_73_626 VPWR VGND sg13g2_decap_8
XFILLER_72_147 VPWR VGND sg13g2_fill_2
XFILLER_54_57 VPWR VGND sg13g2_fill_1
XFILLER_9_207 VPWR VGND sg13g2_decap_8
XFILLER_9_229 VPWR VGND sg13g2_decap_8
XFILLER_9_218 VPWR VGND sg13g2_fill_1
XFILLER_70_34 VPWR VGND sg13g2_decap_8
XFILLER_0_140 VPWR VGND sg13g2_fill_1
XFILLER_49_612 VPWR VGND sg13g2_fill_1
XFILLER_36_317 VPWR VGND sg13g2_fill_1
XFILLER_48_166 VPWR VGND sg13g2_decap_8
XFILLER_76_475 VPWR VGND sg13g2_decap_8
XFILLER_76_464 VPWR VGND sg13g2_fill_1
XFILLER_17_520 VPWR VGND sg13g2_decap_8
XFILLER_64_648 VPWR VGND sg13g2_decap_4
XFILLER_63_136 VPWR VGND sg13g2_decap_8
XFILLER_32_534 VPWR VGND sg13g2_decap_4
X_3780_ _3785_/C _3847_/B _3844_/B VPWR VGND sg13g2_nand2_1
X_2800_ _2800_/X _5428_/Q _2800_/B VPWR VGND sg13g2_and2_1
X_2731_ _2736_/A _5242_/Q _2938_/B VPWR VGND sg13g2_nand2_1
X_5450_ _5450_/X _5450_/A VPWR VGND sg13g2_buf_1
X_4401_ _5256_/D _3932_/B hold788/X _4409_/S VPWR VGND sg13g2_mux2_1
X_2662_ _2999_/C _2677_/A _4521_/A VPWR VGND sg13g2_nand2b_1
XFILLER_8_284 VPWR VGND sg13g2_fill_1
X_5381_ _5381_/Q clkload5/A _5381_/D _5121_/Y VPWR VGND sg13g2_dfrbpq_1
X_2593_ _2593_/Y input3/X VPWR VGND sg13g2_inv_1
X_4332_ _5314_/D _4085_/Y hold727/X _4335_/B VPWR VGND sg13g2_mux2_1
XFILLER_5_51 VPWR VGND sg13g2_decap_8
X_4263_ _4263_/Y _4263_/A _4273_/S VPWR VGND sg13g2_nor2_1
X_3214_ _3217_/B _4139_/A1 _3204_/A _3205_/X _3206_/Y VPWR VGND sg13g2_a22oi_1
X_4194_ _4194_/X _4194_/A1 _4475_/B _4193_/Y VPWR VGND sg13g2_a21o_1
XFILLER_39_166 VPWR VGND sg13g2_fill_1
X_3145_ _3145_/Y _3144_/A _3166_/B _3144_/Y VPWR VGND sg13g2_o21ai_1
X_3076_ _3076_/Y _3018_/Y _3269_/B _3096_/B VPWR VGND sg13g2_nand3b_1
XFILLER_42_309 VPWR VGND sg13g2_decap_4
XFILLER_35_361 VPWR VGND sg13g2_fill_2
XFILLER_24_16 VPWR VGND sg13g2_decap_8
XFILLER_50_342 VPWR VGND sg13g2_decap_4
XFILLER_62_180 VPWR VGND sg13g2_fill_1
XFILLER_23_589 VPWR VGND sg13g2_decap_8
X_3978_ _3985_/B _3978_/A _3978_/B _3978_/C _3978_/D VPWR VGND sg13g2_nor4_1
X_2929_ _2930_/D _5432_/Q _2841_/B _3369_/B1 _5400_/Q VPWR VGND sg13g2_a22oi_1
XFILLER_2_427 VPWR VGND sg13g2_fill_1
XFILLER_6_7 VPWR VGND sg13g2_decap_4
XFILLER_49_35 VPWR VGND sg13g2_decap_8
XFILLER_46_637 VPWR VGND sg13g2_decap_8
XFILLER_73_445 VPWR VGND sg13g2_decap_8
XFILLER_73_478 VPWR VGND sg13g2_decap_4
XFILLER_73_456 VPWR VGND sg13g2_fill_2
XFILLER_26_383 VPWR VGND sg13g2_decap_8
XFILLER_14_545 VPWR VGND sg13g2_decap_8
XFILLER_53_180 VPWR VGND sg13g2_fill_1
XFILLER_81_66 VPWR VGND sg13g2_decap_8
XFILLER_14_93 VPWR VGND sg13g2_decap_8
XFILLER_5_254 VPWR VGND sg13g2_decap_4
XFILLER_30_92 VPWR VGND sg13g2_decap_4
XFILLER_5_287 VPWR VGND sg13g2_decap_8
XFILLER_1_482 VPWR VGND sg13g2_decap_8
Xinput8 input8/X dmem_rdata[16] VPWR VGND sg13g2_buf_1
XFILLER_36_169 VPWR VGND sg13g2_fill_1
XFILLER_64_467 VPWR VGND sg13g2_fill_1
XFILLER_51_128 VPWR VGND sg13g2_decap_8
X_4950_ _4950_/Y _4951_/A VPWR VGND sg13g2_inv_1
XFILLER_32_331 VPWR VGND sg13g2_decap_8
XFILLER_51_139 VPWR VGND sg13g2_fill_2
X_4881_ _4881_/Y _4885_/B _4881_/B VPWR VGND sg13g2_xnor2_1
X_3901_ _3901_/Y _3901_/A _3901_/B _3901_/C VPWR VGND sg13g2_nand3_1
X_3832_ _3832_/Y _3879_/A _3681_/B _4045_/A VPWR VGND sg13g2_o21ai_1
XFILLER_20_559 VPWR VGND sg13g2_fill_2
X_3763_ _3825_/B _4448_/B _3763_/B _3763_/C _3763_/D VPWR VGND sg13g2_nor4_1
X_3694_ _3701_/A _4629_/B _3693_/B _3634_/A VPWR VGND sg13g2_o21ai_1
X_2714_ _2926_/B _2714_/A _2714_/B VPWR VGND sg13g2_and2_1
X_5433_ _5433_/Q clkload7/A _5433_/D _5173_/Y VPWR VGND sg13g2_dfrbpq_1
X_2645_ _2645_/Y _4489_/B _2956_/B _2659_/B _2999_/B VPWR VGND sg13g2_nor4_1
X_5364_ _5364_/Q _5435_/CLK _5364_/D _5104_/Y VPWR VGND sg13g2_dfrbpq_1
X_4315_ _5329_/D _4278_/A hold834/X _4317_/S VPWR VGND sg13g2_mux2_1
X_2576_ _4660_/A _2576_/A VPWR VGND sg13g2_inv_1
X_5295_ _5295_/Q _5424_/CLK _5295_/D _5035_/Y VPWR VGND sg13g2_dfrbpq_1
X_4246_ _5383_/D hold807/X _3953_/Y _4247_/S VPWR VGND sg13g2_mux2_1
X_4177_ _4177_/Y _4913_/A _4177_/A2 _4178_/A2 VPWR VGND sg13g2_a21oi_1
XFILLER_55_401 VPWR VGND sg13g2_decap_8
XFILLER_27_103 VPWR VGND sg13g2_decap_8
X_3128_ _3131_/B _3139_/A _3139_/B _2951_/B VPWR VGND sg13g2_a21oi_1
XFILLER_55_445 VPWR VGND sg13g2_fill_2
XFILLER_35_37 VPWR VGND sg13g2_decap_8
X_3059_ _3060_/D _3059_/A _4198_/A VPWR VGND sg13g2_nor2b_1
XFILLER_51_651 VPWR VGND sg13g2_fill_1
XFILLER_78_526 VPWR VGND sg13g2_fill_1
Xfanout550 fanout550/X fanout565/X VPWR VGND sg13g2_buf_1
XFILLER_76_11 VPWR VGND sg13g2_fill_1
Xfanout561 _5142_/A fanout564/X VPWR VGND sg13g2_buf_1
Xfanout572 _4489_/B input52/X VPWR VGND sg13g2_buf_1
Xfanout583 _3365_/A2 input48/X VPWR VGND sg13g2_buf_1
Xfanout594 _4913_/A _4879_/A VPWR VGND sg13g2_buf_1
XFILLER_18_158 VPWR VGND sg13g2_decap_4
XFILLER_46_456 VPWR VGND sg13g2_decap_8
XFILLER_33_106 VPWR VGND sg13g2_decap_8
XFILLER_61_404 VPWR VGND sg13g2_decap_8
XFILLER_61_459 VPWR VGND sg13g2_decap_8
XFILLER_14_342 VPWR VGND sg13g2_decap_4
XFILLER_25_70 VPWR VGND sg13g2_fill_1
XFILLER_25_92 VPWR VGND sg13g2_decap_4
XFILLER_41_194 VPWR VGND sg13g2_decap_8
XFILLER_10_592 VPWR VGND sg13g2_fill_2
XFILLER_6_530 VPWR VGND sg13g2_fill_1
XFILLER_6_596 VPWR VGND sg13g2_decap_8
X_5080_ _5080_/Y _5144_/A VPWR VGND sg13g2_inv_1
X_4100_ _4102_/B _4100_/A _4100_/B VPWR VGND sg13g2_nor2_1
X_4031_ _4032_/B _3823_/A _4030_/X _4028_/Y VPWR VGND sg13g2_o21ai_1
XFILLER_56_209 VPWR VGND sg13g2_decap_8
XFILLER_37_423 VPWR VGND sg13g2_fill_1
XFILLER_37_445 VPWR VGND sg13g2_decap_8
XFILLER_64_220 VPWR VGND sg13g2_fill_2
XFILLER_52_426 VPWR VGND sg13g2_fill_1
XFILLER_52_437 VPWR VGND sg13g2_fill_2
X_4933_ _4933_/Y _5161_/A VPWR VGND sg13g2_inv_1
XFILLER_64_297 VPWR VGND sg13g2_decap_8
XFILLER_32_161 VPWR VGND sg13g2_fill_2
X_4864_ _4873_/B _4876_/A _4876_/C VPWR VGND sg13g2_xor2_1
XFILLER_20_345 VPWR VGND sg13g2_fill_1
X_4795_ _4796_/B _4808_/C _4809_/B _4795_/C VPWR VGND sg13g2_nand3_1
X_3815_ _3815_/Y _2621_/Y _3889_/B _3813_/Y _3814_/Y VPWR VGND sg13g2_a22oi_1
XFILLER_20_389 VPWR VGND sg13g2_decap_8
X_3746_ _3746_/Y _3746_/A _3746_/B VPWR VGND sg13g2_xnor2_1
X_5416_ _5416_/Q clkload8/A _5416_/D _5156_/Y VPWR VGND sg13g2_dfrbpq_1
X_3677_ _3678_/D _5260_/Q _3677_/B VPWR VGND sg13g2_nand2_1
Xoutput142 dmem_wdata[1] _5437_/A VPWR VGND sg13g2_buf_1
Xoutput131 dmem_wdata[0] _5436_/A VPWR VGND sg13g2_buf_1
Xoutput120 dmem_addr[2] _4529_/Y VPWR VGND sg13g2_buf_1
X_2628_ _4761_/A _2628_/A VPWR VGND sg13g2_inv_1
X_5347_ _5347_/Q _5414_/CLK _5347_/D _5087_/Y VPWR VGND sg13g2_dfrbpq_1
Xoutput153 dmem_wdata[2] _5438_/A VPWR VGND sg13g2_buf_1
Xoutput164 imem_addr[0] _5225_/Q VPWR VGND sg13g2_buf_1
Xoutput175 imem_addr[1] _5226_/Q VPWR VGND sg13g2_buf_1
Xoutput186 imem_addr[2] _5195_/Q VPWR VGND sg13g2_buf_1
X_2559_ _2941_/A _2559_/A VPWR VGND sg13g2_inv_1
X_5278_ _5278_/Q _5424_/CLK _5278_/D _5018_/Y VPWR VGND sg13g2_dfrbpq_1
Xoutput197 io_wdata[0] _5436_/X VPWR VGND sg13g2_buf_1
X_4229_ _5397_/D hold840/X _3198_/Y _4237_/S VPWR VGND sg13g2_mux2_1
XFILLER_46_36 VPWR VGND sg13g2_decap_8
XFILLER_46_47 VPWR VGND sg13g2_fill_2
XFILLER_62_35 VPWR VGND sg13g2_decap_8
XFILLER_11_345 VPWR VGND sg13g2_decap_8
XFILLER_3_522 VPWR VGND sg13g2_decap_4
XFILLER_78_334 VPWR VGND sg13g2_decap_4
XFILLER_78_323 VPWR VGND sg13g2_fill_2
XFILLER_78_312 VPWR VGND sg13g2_decap_8
Xfanout380 _3011_/A _4441_/B VPWR VGND sg13g2_buf_1
Xfanout391 _3921_/A _4100_/A VPWR VGND sg13g2_buf_1
XFILLER_59_592 VPWR VGND sg13g2_decap_8
XFILLER_46_297 VPWR VGND sg13g2_decap_8
XFILLER_61_278 VPWR VGND sg13g2_decap_8
XFILLER_14_161 VPWR VGND sg13g2_decap_8
Xinput22 _2620_/A dmem_rdata[29] VPWR VGND sg13g2_buf_1
Xinput11 _2605_/A dmem_rdata[19] VPWR VGND sg13g2_buf_1
X_4580_ _4583_/A _5451_/A _4580_/B VPWR VGND sg13g2_nand2_1
X_3600_ _3916_/B _3600_/A _3739_/A VPWR VGND sg13g2_nand2_1
Xinput55 _4644_/A imem_data[2] VPWR VGND sg13g2_buf_1
Xinput44 _4494_/B imem_data[1] VPWR VGND sg13g2_buf_1
Xinput33 _4524_/A imem_data[0] VPWR VGND sg13g2_buf_1
X_3531_ _3531_/Y _3531_/A _3531_/B _3531_/C _3531_/D VPWR VGND sg13g2_nand4_1
Xinput88 _3813_/A io_rdata[30] VPWR VGND sg13g2_buf_1
Xinput77 _2606_/A io_rdata[20] VPWR VGND sg13g2_buf_1
Xinput66 _2590_/A io_rdata[10] VPWR VGND sg13g2_buf_1
Xhold828 hold828/X _5194_/Q VPWR VGND sg13g2_dlygate4sd3_1
Xhold817 hold817/X _5349_/Q VPWR VGND sg13g2_dlygate4sd3_1
Xhold806 hold806/X _5177_/Q VPWR VGND sg13g2_dlygate4sd3_1
Xhold839 _4496_/A _5226_/Q VPWR VGND sg13g2_dlygate4sd3_1
X_3462_ _3462_/Y _3462_/A _3460_/Y VPWR VGND sg13g2_nor2b_1
X_5201_ _5201_/Q _5206_/CLK _5201_/D _4941_/Y VPWR VGND sg13g2_dfrbpq_1
X_3393_ _3393_/X _4160_/A _3418_/B VPWR VGND sg13g2_and2_1
X_5132_ _5132_/Y _5132_/A VPWR VGND sg13g2_inv_1
XFILLER_28_0 VPWR VGND sg13g2_decap_8
XFILLER_69_345 VPWR VGND sg13g2_fill_2
X_5063_ _5063_/Y _5153_/A VPWR VGND sg13g2_inv_1
XFILLER_69_389 VPWR VGND sg13g2_decap_8
XFILLER_37_220 VPWR VGND sg13g2_fill_1
X_4014_ _4014_/X _3574_/A _3574_/B _4030_/A VPWR VGND sg13g2_a21o_1
XFILLER_37_275 VPWR VGND sg13g2_fill_1
XFILLER_37_286 VPWR VGND sg13g2_decap_8
XFILLER_52_223 VPWR VGND sg13g2_decap_8
XFILLER_80_543 VPWR VGND sg13g2_fill_1
XFILLER_40_418 VPWR VGND sg13g2_decap_4
X_4916_ _5224_/D _4914_/A _4915_/Y _4914_/Y VPWR VGND sg13g2_a21oi_1
X_4847_ _4848_/D _4814_/B _4840_/B _4840_/A VPWR VGND sg13g2_o21ai_1
X_4778_ _5209_/D _4796_/A _4774_/B _4777_/Y VPWR VGND sg13g2_o21ai_1
X_3729_ _4132_/C _3729_/A _3729_/B _3729_/C VPWR VGND sg13g2_nand3_1
XFILLER_0_514 VPWR VGND sg13g2_decap_8
XFILLER_48_529 VPWR VGND sg13g2_decap_8
XFILLER_75_337 VPWR VGND sg13g2_decap_8
XFILLER_28_253 VPWR VGND sg13g2_decap_4
XFILLER_56_551 VPWR VGND sg13g2_decap_8
XFILLER_12_621 VPWR VGND sg13g2_fill_2
XFILLER_31_418 VPWR VGND sg13g2_fill_2
XFILLER_71_587 VPWR VGND sg13g2_decap_8
XFILLER_11_197 VPWR VGND sg13g2_decap_8
XFILLER_22_82 VPWR VGND sg13g2_decap_8
XFILLER_7_179 VPWR VGND sg13g2_fill_1
XFILLER_3_341 VPWR VGND sg13g2_decap_8
XFILLER_3_396 VPWR VGND sg13g2_decap_4
XFILLER_79_621 VPWR VGND sg13g2_fill_1
XFILLER_21_7 VPWR VGND sg13g2_decap_4
XFILLER_22_407 VPWR VGND sg13g2_fill_1
X_2962_ _4185_/B _2999_/B _2961_/Y _3878_/A VPWR VGND sg13g2_o21ai_1
X_4701_ _5201_/D _4701_/A1 _4697_/B _4700_/Y VPWR VGND sg13g2_o21ai_1
X_4632_ _4632_/Y _4641_/A _5464_/A VPWR VGND sg13g2_nand2_1
X_2893_ _3225_/A _3248_/A _2912_/B VPWR VGND sg13g2_nor2_1
X_4563_ _4565_/A _4556_/S _5448_/A _4562_/X VPWR VGND sg13g2_a21oi_1
Xhold614 _4483_/A _5227_/Q VPWR VGND sg13g2_dlygate4sd3_1
Xhold625 _2557_/A _5311_/Q VPWR VGND sg13g2_dlygate4sd3_1
Xhold636 _2539_/A _5416_/Q VPWR VGND sg13g2_dlygate4sd3_1
X_4494_ _4495_/B _4496_/A _4494_/B VPWR VGND sg13g2_xnor2_1
X_3514_ _3514_/Y _3514_/A _3512_/Y VPWR VGND sg13g2_nor2b_1
Xhold647 _2545_/A _5377_/Q VPWR VGND sg13g2_dlygate4sd3_1
Xhold658 hold658/X _5249_/Q VPWR VGND sg13g2_dlygate4sd3_1
Xhold669 hold669/X _5233_/Q VPWR VGND sg13g2_dlygate4sd3_1
X_3445_ _3445_/Y _5318_/Q _3674_/A2 _3674_/B1 _5286_/Q _3443_/Y VPWR VGND sg13g2_a221oi_1
X_3376_ _3726_/A _4162_/B _3417_/B VPWR VGND sg13g2_nand2b_1
X_5115_ _5115_/Y _5149_/A VPWR VGND sg13g2_inv_1
XFILLER_69_186 VPWR VGND sg13g2_decap_4
XFILLER_69_164 VPWR VGND sg13g2_fill_1
XFILLER_57_315 VPWR VGND sg13g2_decap_8
XFILLER_38_540 VPWR VGND sg13g2_fill_2
X_5046_ _5046_/Y _5174_/A VPWR VGND sg13g2_inv_1
XFILLER_38_562 VPWR VGND sg13g2_decap_8
XFILLER_65_381 VPWR VGND sg13g2_fill_1
XFILLER_53_521 VPWR VGND sg13g2_decap_8
XFILLER_53_543 VPWR VGND sg13g2_decap_8
XFILLER_40_215 VPWR VGND sg13g2_fill_1
XFILLER_21_462 VPWR VGND sg13g2_fill_1
XFILLER_4_116 VPWR VGND sg13g2_decap_8
XFILLER_0_322 VPWR VGND sg13g2_fill_1
XFILLER_75_189 VPWR VGND sg13g2_fill_2
XFILLER_16_256 VPWR VGND sg13g2_fill_1
XFILLER_44_554 VPWR VGND sg13g2_decap_8
XFILLER_71_340 VPWR VGND sg13g2_fill_2
XFILLER_16_267 VPWR VGND sg13g2_fill_2
XFILLER_71_362 VPWR VGND sg13g2_fill_1
XFILLER_12_451 VPWR VGND sg13g2_decap_8
XFILLER_12_462 VPWR VGND sg13g2_fill_1
XFILLER_33_70 VPWR VGND sg13g2_fill_2
XFILLER_8_411 VPWR VGND sg13g2_decap_8
X_3230_ _3231_/C _3210_/A _3025_/B _3025_/A VPWR VGND sg13g2_a21oi_1
X_3161_ _3161_/Y _3161_/A _3161_/B VPWR VGND sg13g2_xnor2_1
XFILLER_66_123 VPWR VGND sg13g2_fill_2
X_3092_ _3092_/Y _2574_/A _3135_/A2 _3154_/B1 VPWR VGND sg13g2_a21oi_1
XFILLER_66_167 VPWR VGND sg13g2_decap_8
XFILLER_81_115 VPWR VGND sg13g2_decap_8
XFILLER_35_576 VPWR VGND sg13g2_decap_4
XFILLER_35_587 VPWR VGND sg13g2_decap_8
XFILLER_50_502 VPWR VGND sg13g2_decap_8
XFILLER_22_237 VPWR VGND sg13g2_decap_8
XFILLER_50_568 VPWR VGND sg13g2_fill_2
X_3994_ _4008_/B _4041_/A _3994_/B VPWR VGND sg13g2_nand2_1
X_2945_ _5444_/A _2942_/Y _2943_/Y _2944_/Y VPWR VGND sg13g2_a21oi_1
X_2876_ _2876_/Y _2871_/Y _2873_/Y _2874_/Y VPWR VGND sg13g2_a21oi_1
X_4615_ _4615_/Y _4615_/A1 _4638_/A _5459_/A _4618_/B2 VPWR VGND sg13g2_a22oi_1
X_4546_ _4548_/B _4688_/A _5443_/A _4556_/S VPWR VGND sg13g2_mux2_1
X_4477_ _4478_/D _4477_/A _4477_/B _4477_/C _4477_/D VPWR VGND sg13g2_nor4_1
X_3428_ _3432_/A _5253_/Q _3677_/B VPWR VGND sg13g2_nand2_1
X_3359_ _3359_/Y _3764_/A _3359_/B VPWR VGND sg13g2_xnor2_1
XFILLER_58_602 VPWR VGND sg13g2_decap_8
XFILLER_57_101 VPWR VGND sg13g2_decap_4
XFILLER_38_37 VPWR VGND sg13g2_fill_1
XFILLER_57_156 VPWR VGND sg13g2_decap_4
XFILLER_57_145 VPWR VGND sg13g2_fill_1
XFILLER_26_521 VPWR VGND sg13g2_decap_8
XFILLER_38_381 VPWR VGND sg13g2_decap_4
XFILLER_45_329 VPWR VGND sg13g2_decap_8
X_5029_ _5029_/Y _5125_/A VPWR VGND sg13g2_inv_1
XFILLER_72_115 VPWR VGND sg13g2_fill_2
XFILLER_72_104 VPWR VGND sg13g2_decap_8
XFILLER_54_36 VPWR VGND sg13g2_fill_2
XFILLER_26_598 VPWR VGND sg13g2_decap_8
XFILLER_53_373 VPWR VGND sg13g2_decap_8
XFILLER_13_226 VPWR VGND sg13g2_fill_2
XFILLER_80_181 VPWR VGND sg13g2_fill_1
XFILLER_21_270 VPWR VGND sg13g2_fill_2
XFILLER_1_631 VPWR VGND sg13g2_decap_8
XFILLER_48_145 VPWR VGND sg13g2_decap_8
XFILLER_29_370 VPWR VGND sg13g2_fill_1
XFILLER_48_178 VPWR VGND sg13g2_fill_2
XFILLER_71_170 VPWR VGND sg13g2_decap_8
XFILLER_32_568 VPWR VGND sg13g2_decap_4
X_2730_ _2730_/Y _3011_/A _2730_/B VPWR VGND sg13g2_xnor2_1
XFILLER_12_292 VPWR VGND sg13g2_decap_4
X_2661_ _3000_/C _2677_/A _4521_/A VPWR VGND sg13g2_nor2b_1
XFILLER_8_241 VPWR VGND sg13g2_fill_2
X_4400_ _5257_/D _3908_/X hold744/X _4407_/S VPWR VGND sg13g2_mux2_1
XFILLER_67_4 VPWR VGND sg13g2_decap_8
X_5380_ _5380_/Q clkload6/A _5380_/D _5120_/Y VPWR VGND sg13g2_dfrbpq_1
X_2592_ _2592_/Y _2592_/A VPWR VGND sg13g2_inv_1
X_4331_ _5315_/D _4059_/Y hold728/X _4335_/B VPWR VGND sg13g2_mux2_1
X_4262_ _5372_/D _2549_/Y _4280_/B _4261_/Y VPWR VGND sg13g2_o21ai_1
X_3213_ _3213_/Y _4435_/B _3166_/B _3211_/Y VPWR VGND sg13g2_o21ai_1
X_4193_ _4193_/Y input70/X _4194_/A1 _2658_/Y VPWR VGND sg13g2_o21ai_1
XFILLER_10_0 VPWR VGND sg13g2_decap_4
XFILLER_27_307 VPWR VGND sg13g2_fill_1
X_3144_ _3144_/Y _3144_/A _3187_/B VPWR VGND sg13g2_nand2_1
XFILLER_67_454 VPWR VGND sg13g2_decap_8
XFILLER_55_616 VPWR VGND sg13g2_fill_2
XFILLER_55_605 VPWR VGND sg13g2_decap_8
X_3075_ _3075_/Y _3269_/B _3072_/Y _3074_/Y _4133_/A VPWR VGND sg13g2_a22oi_1
XFILLER_54_126 VPWR VGND sg13g2_fill_1
XFILLER_35_340 VPWR VGND sg13g2_decap_8
XFILLER_54_148 VPWR VGND sg13g2_decap_8
XFILLER_54_137 VPWR VGND sg13g2_fill_1
XFILLER_23_524 VPWR VGND sg13g2_decap_8
XFILLER_50_321 VPWR VGND sg13g2_decap_8
XFILLER_23_568 VPWR VGND sg13g2_fill_2
X_3977_ _3978_/D _3977_/A _3977_/B VPWR VGND sg13g2_nand2_1
XFILLER_50_387 VPWR VGND sg13g2_fill_1
X_2928_ _2930_/A _5272_/Q _3371_/A2 _3371_/B1 _5336_/Q VPWR VGND sg13g2_a22oi_1
X_2859_ _2859_/X _5424_/Q _3397_/B VPWR VGND sg13g2_and2_1
X_4529_ _4529_/Y _4531_/A _4529_/B VPWR VGND sg13g2_xnor2_1
XFILLER_49_14 VPWR VGND sg13g2_decap_8
XFILLER_77_218 VPWR VGND sg13g2_decap_8
XFILLER_58_421 VPWR VGND sg13g2_decap_8
XFILLER_46_616 VPWR VGND sg13g2_decap_4
XFILLER_18_329 VPWR VGND sg13g2_decap_8
XFILLER_26_340 VPWR VGND sg13g2_decap_8
XFILLER_61_619 VPWR VGND sg13g2_decap_8
XFILLER_14_524 VPWR VGND sg13g2_decap_8
XFILLER_81_45 VPWR VGND sg13g2_decap_8
XFILLER_22_590 VPWR VGND sg13g2_decap_8
XFILLER_30_71 VPWR VGND sg13g2_decap_8
XFILLER_39_8 VPWR VGND sg13g2_decap_8
XFILLER_68_229 VPWR VGND sg13g2_fill_1
XFILLER_68_207 VPWR VGND sg13g2_fill_2
XFILLER_49_410 VPWR VGND sg13g2_decap_8
XFILLER_49_454 VPWR VGND sg13g2_decap_8
XFILLER_36_104 VPWR VGND sg13g2_decap_8
XFILLER_49_498 VPWR VGND sg13g2_decap_8
Xinput9 input9/X dmem_rdata[17] VPWR VGND sg13g2_buf_1
XFILLER_64_402 VPWR VGND sg13g2_decap_4
XFILLER_17_362 VPWR VGND sg13g2_decap_8
XFILLER_44_170 VPWR VGND sg13g2_decap_4
X_4880_ _4881_/B _4880_/A _4880_/B VPWR VGND sg13g2_nor2_1
X_3900_ _3901_/C _3102_/A _3739_/C _3899_/Y VPWR VGND sg13g2_a21oi_1
XFILLER_60_641 VPWR VGND sg13g2_decap_8
X_3831_ _3836_/C _4116_/A _3847_/B _3830_/Y VPWR VGND sg13g2_o21ai_1
XFILLER_20_527 VPWR VGND sg13g2_decap_8
X_3762_ _3874_/A _4448_/B _3996_/A _3763_/D VPWR VGND sg13g2_nor3_1
X_3693_ _5464_/A _4629_/B _3693_/B VPWR VGND sg13g2_nor2_1
X_2713_ _2713_/X _2723_/C _2723_/B VPWR VGND sg13g2_or2_1
XFILLER_9_594 VPWR VGND sg13g2_decap_8
XFILLER_9_572 VPWR VGND sg13g2_decap_8
X_5432_ _5432_/Q _5432_/CLK _5432_/D _5172_/Y VPWR VGND sg13g2_dfrbpq_1
X_2644_ _2673_/B _4489_/B _2956_/B VPWR VGND sg13g2_nor2_1
X_5363_ _5363_/Q _5426_/CLK _5363_/D _5103_/Y VPWR VGND sg13g2_dfrbpq_1
X_2575_ _4697_/A _2575_/A VPWR VGND sg13g2_inv_1
X_4314_ _5330_/D _4355_/A hold780/X _4317_/S VPWR VGND sg13g2_mux2_1
X_5294_ _5294_/Q clkload2/A _5294_/D _5034_/Y VPWR VGND sg13g2_dfrbpq_1
X_4245_ _5384_/D hold680/X _3932_/B _4247_/S VPWR VGND sg13g2_mux2_1
XFILLER_28_605 VPWR VGND sg13g2_decap_8
X_4176_ _4176_/Y _4176_/A1 _4481_/D _4175_/Y VPWR VGND sg13g2_o21ai_1
X_3127_ _3127_/X _3127_/A _3127_/B _3127_/C VPWR VGND sg13g2_or3_1
XFILLER_67_284 VPWR VGND sg13g2_decap_8
XFILLER_43_608 VPWR VGND sg13g2_decap_4
X_3058_ _3059_/A _2730_/Y _3055_/B _3269_/B VPWR VGND sg13g2_o21ai_1
XFILLER_70_427 VPWR VGND sg13g2_decap_8
XFILLER_55_479 VPWR VGND sg13g2_decap_8
XFILLER_11_505 VPWR VGND sg13g2_decap_8
XFILLER_23_365 VPWR VGND sg13g2_decap_4
XFILLER_50_173 VPWR VGND sg13g2_fill_1
XFILLER_51_37 VPWR VGND sg13g2_decap_4
Xfanout540 _5147_/A _5092_/A VPWR VGND sg13g2_buf_1
Xfanout551 _5164_/A _5144_/A VPWR VGND sg13g2_buf_1
XFILLER_19_605 VPWR VGND sg13g2_decap_8
Xfanout562 _5172_/A fanout564/X VPWR VGND sg13g2_buf_1
Xfanout573 _4523_/A input52/X VPWR VGND sg13g2_buf_1
Xfanout584 _2723_/B _2716_/C VPWR VGND sg13g2_buf_1
Xfanout595 _4879_/A input39/X VPWR VGND sg13g2_buf_1
XFILLER_46_435 VPWR VGND sg13g2_decap_8
XFILLER_73_287 VPWR VGND sg13g2_fill_2
XFILLER_61_449 VPWR VGND sg13g2_fill_2
XFILLER_61_438 VPWR VGND sg13g2_decap_8
XFILLER_54_490 VPWR VGND sg13g2_decap_4
XFILLER_25_60 VPWR VGND sg13g2_fill_1
XFILLER_14_398 VPWR VGND sg13g2_decap_8
XFILLER_6_575 VPWR VGND sg13g2_decap_8
XFILLER_69_505 VPWR VGND sg13g2_fill_2
X_4030_ _4030_/X _4030_/A _4030_/B VPWR VGND sg13g2_xor2_1
XFILLER_2_86 VPWR VGND sg13g2_fill_1
XFILLER_77_593 VPWR VGND sg13g2_decap_4
XFILLER_25_608 VPWR VGND sg13g2_decap_8
XFILLER_64_276 VPWR VGND sg13g2_fill_2
X_4932_ _4932_/Y _5125_/A VPWR VGND sg13g2_inv_1
X_4863_ _5218_/D _4878_/A _4861_/X _4862_/Y VPWR VGND sg13g2_a21oi_1
XFILLER_32_195 VPWR VGND sg13g2_decap_8
X_4794_ _4794_/Y _4809_/B _4795_/C _4808_/C VPWR VGND sg13g2_a21oi_1
X_3814_ _3814_/Y _3887_/B _4479_/A _3065_/Y VPWR VGND sg13g2_a21oi_1
X_3745_ _3746_/B _3358_/Y _3744_/Y _3357_/Y VPWR VGND sg13g2_a21o_1
XFILLER_9_380 VPWR VGND sg13g2_fill_1
X_5415_ _5415_/Q clkload1/A _5415_/D _5155_/Y VPWR VGND sg13g2_dfrbpq_1
Xoutput110 dmem_addr[20] _4604_/Y VPWR VGND sg13g2_buf_1
X_3676_ _3678_/C _5388_/Q _3676_/A2 _3676_/B1 _5356_/Q VPWR VGND sg13g2_a22oi_1
Xoutput143 dmem_wdata[20] _5456_/A VPWR VGND sg13g2_buf_1
Xoutput132 dmem_wdata[10] _5446_/A VPWR VGND sg13g2_buf_1
Xoutput121 dmem_addr[30] _4640_/Y VPWR VGND sg13g2_buf_1
X_2627_ _2627_/Y _2627_/A VPWR VGND sg13g2_inv_1
X_5346_ _5346_/Q clkload6/A _5346_/D _5086_/Y VPWR VGND sg13g2_dfrbpq_1
Xoutput154 dmem_wdata[30] _5466_/A VPWR VGND sg13g2_buf_1
Xoutput165 imem_addr[10] _5203_/Q VPWR VGND sg13g2_buf_1
Xoutput176 imem_addr[20] _5213_/Q VPWR VGND sg13g2_buf_1
X_2558_ _2558_/Y _2558_/A VPWR VGND sg13g2_inv_1
X_5277_ _5277_/Q _5430_/CLK _5277_/D _5017_/Y VPWR VGND sg13g2_dfrbpq_1
Xoutput187 imem_addr[30] _5223_/Q VPWR VGND sg13g2_buf_1
Xoutput198 io_wdata[10] _5446_/X VPWR VGND sg13g2_buf_1
X_4228_ _5398_/D hold698/X _4348_/A _4236_/S VPWR VGND sg13g2_mux2_1
XFILLER_28_402 VPWR VGND sg13g2_fill_1
X_4159_ _4168_/A _4159_/A _4159_/B VPWR VGND sg13g2_nor2_1
XFILLER_55_210 VPWR VGND sg13g2_decap_8
XFILLER_16_619 VPWR VGND sg13g2_fill_2
XFILLER_28_479 VPWR VGND sg13g2_decap_8
XFILLER_43_416 VPWR VGND sg13g2_decap_8
XFILLER_43_438 VPWR VGND sg13g2_decap_8
XFILLER_70_235 VPWR VGND sg13g2_decap_8
XFILLER_70_257 VPWR VGND sg13g2_decap_8
XFILLER_70_246 VPWR VGND sg13g2_fill_1
XFILLER_23_151 VPWR VGND sg13g2_fill_1
XFILLER_11_324 VPWR VGND sg13g2_decap_8
XFILLER_23_184 VPWR VGND sg13g2_decap_4
XFILLER_7_306 VPWR VGND sg13g2_fill_1
XFILLER_3_545 VPWR VGND sg13g2_decap_8
XFILLER_78_346 VPWR VGND sg13g2_fill_2
Xfanout370 _3148_/A _4436_/C VPWR VGND sg13g2_buf_1
Xfanout381 _4441_/B fanout381/A VPWR VGND sg13g2_buf_1
Xfanout392 _4207_/A _4100_/A VPWR VGND sg13g2_buf_1
XFILLER_34_405 VPWR VGND sg13g2_decap_8
XFILLER_46_276 VPWR VGND sg13g2_decap_8
XFILLER_14_140 VPWR VGND sg13g2_decap_8
XFILLER_61_246 VPWR VGND sg13g2_decap_4
Xinput12 _2580_/A dmem_rdata[1] VPWR VGND sg13g2_buf_1
XFILLER_52_80 VPWR VGND sg13g2_decap_8
Xinput45 input45/X imem_data[20] VPWR VGND sg13g2_buf_2
Xinput34 _4712_/A imem_data[10] VPWR VGND sg13g2_buf_1
Xinput23 _2582_/A dmem_rdata[2] VPWR VGND sg13g2_buf_1
X_3530_ _4114_/A _3531_/A _3531_/B _3531_/C _3531_/D VPWR VGND sg13g2_and4_1
Xinput89 input89/X io_rdata[31] VPWR VGND sg13g2_buf_1
Xinput78 _2608_/A io_rdata[21] VPWR VGND sg13g2_buf_1
Xinput67 _2592_/A io_rdata[11] VPWR VGND sg13g2_buf_1
Xinput56 _2653_/B imem_data[30] VPWR VGND sg13g2_buf_1
Xhold818 hold818/X _5296_/Q VPWR VGND sg13g2_dlygate4sd3_1
Xhold807 hold807/X _5383_/Q VPWR VGND sg13g2_dlygate4sd3_1
Xhold829 hold829/X _5429_/Q VPWR VGND sg13g2_dlygate4sd3_1
X_3461_ _3462_/A _5251_/Q _4615_/A1 _3671_/B1 VPWR VGND sg13g2_a21oi_1
XFILLER_6_383 VPWR VGND sg13g2_decap_4
X_5200_ _5200_/Q _5206_/CLK _5200_/D _4940_/Y VPWR VGND sg13g2_dfrbpq_1
X_3392_ _3418_/B _4913_/A _5451_/A _3392_/S VPWR VGND sg13g2_mux2_1
X_5131_ _5131_/Y _5164_/A VPWR VGND sg13g2_inv_1
XFILLER_69_324 VPWR VGND sg13g2_decap_8
XFILLER_69_313 VPWR VGND sg13g2_fill_1
X_5062_ _5062_/Y _5095_/A VPWR VGND sg13g2_inv_1
XFILLER_69_357 VPWR VGND sg13g2_decap_4
X_4013_ _5413_/D hold745/X _4012_/Y _4013_/S VPWR VGND sg13g2_mux2_1
XFILLER_77_390 VPWR VGND sg13g2_fill_2
XFILLER_52_202 VPWR VGND sg13g2_decap_8
XFILLER_65_585 VPWR VGND sg13g2_decap_8
XFILLER_18_490 VPWR VGND sg13g2_decap_8
Xclkbuf_leaf_17_clk clkload0/A clkbuf_2_0__f_clk/X VPWR VGND sg13g2_buf_8
XFILLER_80_577 VPWR VGND sg13g2_decap_8
XFILLER_21_622 VPWR VGND sg13g2_fill_1
XFILLER_33_482 VPWR VGND sg13g2_decap_8
XFILLER_52_279 VPWR VGND sg13g2_decap_8
X_4915_ _4915_/Y _4915_/A _4915_/B VPWR VGND sg13g2_xnor2_1
X_4846_ _4849_/A _4846_/A _4846_/B _4846_/C VPWR VGND sg13g2_nor3_1
X_4777_ _4777_/Y _4796_/A _4793_/A _4777_/C VPWR VGND sg13g2_nand3_1
X_3728_ _3729_/C _2759_/Y _3728_/B VPWR VGND sg13g2_nand2b_1
X_3659_ _3659_/Y _4446_/B _3659_/B VPWR VGND sg13g2_nor2_1
X_5329_ _5329_/Q _5427_/CLK _5329_/D _5069_/Y VPWR VGND sg13g2_dfrbpq_1
XFILLER_75_316 VPWR VGND sg13g2_decap_8
XFILLER_57_47 VPWR VGND sg13g2_decap_4
XFILLER_28_210 VPWR VGND sg13g2_decap_8
XFILLER_28_221 VPWR VGND sg13g2_fill_2
XFILLER_68_390 VPWR VGND sg13g2_decap_8
XFILLER_71_500 VPWR VGND sg13g2_fill_2
XFILLER_16_416 VPWR VGND sg13g2_decap_8
XFILLER_28_287 VPWR VGND sg13g2_decap_8
XFILLER_73_24 VPWR VGND sg13g2_decap_8
XFILLER_43_246 VPWR VGND sg13g2_decap_8
XFILLER_73_68 VPWR VGND sg13g2_decap_8
XFILLER_12_633 VPWR VGND sg13g2_decap_8
XFILLER_11_187 VPWR VGND sg13g2_fill_2
XFILLER_22_50 VPWR VGND sg13g2_fill_1
XFILLER_7_147 VPWR VGND sg13g2_decap_4
XFILLER_3_364 VPWR VGND sg13g2_decap_8
XFILLER_78_154 VPWR VGND sg13g2_decap_8
XFILLER_14_7 VPWR VGND sg13g2_fill_2
XFILLER_47_563 VPWR VGND sg13g2_fill_2
XFILLER_19_287 VPWR VGND sg13g2_decap_8
XFILLER_34_213 VPWR VGND sg13g2_decap_8
XFILLER_74_393 VPWR VGND sg13g2_decap_8
XFILLER_62_511 VPWR VGND sg13g2_fill_1
XFILLER_34_257 VPWR VGND sg13g2_decap_8
XFILLER_34_268 VPWR VGND sg13g2_fill_1
X_2961_ _2961_/Y _4521_/B _3000_/C _4520_/B VPWR VGND sg13g2_o21ai_1
XFILLER_62_577 VPWR VGND sg13g2_decap_8
X_4700_ _4700_/Y _4745_/S _4700_/B _4700_/C VPWR VGND sg13g2_nand3_1
X_4631_ _4631_/X _4627_/B _4629_/Y _4633_/B VPWR VGND sg13g2_a21o_1
X_2892_ _2912_/B _4434_/A _3026_/B _2849_/Y _3270_/B _2848_/X VPWR VGND sg13g2_a221oi_1
XFILLER_30_496 VPWR VGND sg13g2_decap_8
X_4562_ _4562_/X _4736_/A _4572_/A VPWR VGND sg13g2_and2_1
Xhold615 _4499_/A _5225_/Q VPWR VGND sg13g2_dlygate4sd3_1
Xhold626 _2560_/A _5302_/Q VPWR VGND sg13g2_dlygate4sd3_1
X_4493_ _4493_/Y _4496_/A _4494_/B VPWR VGND sg13g2_nand2_1
X_3513_ _3514_/A _5249_/Q _2694_/B _3671_/B1 VPWR VGND sg13g2_a21oi_1
Xclkbuf_leaf_6_clk clkload9/A clkbuf_leaf_9_clk/A VPWR VGND sg13g2_buf_8
Xhold637 _3069_/A _5435_/Q VPWR VGND sg13g2_dlygate4sd3_1
Xhold648 hold648/X _5237_/Q VPWR VGND sg13g2_dlygate4sd3_1
Xhold659 hold659/X _5246_/Q VPWR VGND sg13g2_dlygate4sd3_1
X_3444_ _3444_/X _5186_/Q _3644_/B _2714_/B VPWR VGND sg13g2_a21o_1
XFILLER_40_0 VPWR VGND sg13g2_decap_4
X_3375_ _3375_/Y _4438_/A _3417_/B VPWR VGND sg13g2_nor2b_1
XFILLER_69_132 VPWR VGND sg13g2_fill_2
XFILLER_69_121 VPWR VGND sg13g2_decap_8
X_5114_ _5114_/Y _5147_/A VPWR VGND sg13g2_inv_1
X_5045_ _5045_/Y _5134_/A VPWR VGND sg13g2_inv_1
XFILLER_57_349 VPWR VGND sg13g2_decap_8
XFILLER_72_319 VPWR VGND sg13g2_decap_8
XFILLER_53_500 VPWR VGND sg13g2_decap_8
XFILLER_25_213 VPWR VGND sg13g2_fill_2
XFILLER_65_393 VPWR VGND sg13g2_decap_8
XFILLER_25_268 VPWR VGND sg13g2_decap_8
XFILLER_53_599 VPWR VGND sg13g2_decap_8
XFILLER_40_249 VPWR VGND sg13g2_decap_8
XFILLER_21_441 VPWR VGND sg13g2_fill_1
X_4829_ _4829_/Y _4839_/A _4831_/B VPWR VGND sg13g2_nand2b_1
XFILLER_0_389 VPWR VGND sg13g2_decap_4
XFILLER_29_563 VPWR VGND sg13g2_decap_4
XFILLER_44_500 VPWR VGND sg13g2_fill_2
XFILLER_44_533 VPWR VGND sg13g2_decap_8
XFILLER_16_246 VPWR VGND sg13g2_fill_1
XFILLER_17_61 VPWR VGND sg13g2_fill_1
XFILLER_24_290 VPWR VGND sg13g2_decap_8
X_3160_ _3161_/B _3184_/B _3182_/B _2916_/A VPWR VGND sg13g2_o21ai_1
XFILLER_79_463 VPWR VGND sg13g2_fill_1
X_3091_ _3091_/Y _4217_/A1 _4477_/A _3090_/Y VPWR VGND sg13g2_o21ai_1
XFILLER_35_566 VPWR VGND sg13g2_decap_4
XFILLER_47_393 VPWR VGND sg13g2_decap_8
XFILLER_81_149 VPWR VGND sg13g2_fill_1
X_3993_ _3994_/B _3999_/B _3993_/B VPWR VGND sg13g2_xnor2_1
X_2944_ _2944_/Y _5239_/Q _3401_/A2 _3398_/B1 VPWR VGND sg13g2_a21oi_1
X_2875_ _2875_/Y _2564_/Y _2817_/C _2871_/Y _2873_/Y VPWR VGND sg13g2_a22oi_1
X_4614_ _4614_/Y _5459_/A _4614_/B VPWR VGND sg13g2_xnor2_1
X_4545_ _4545_/Y _4542_/B _4544_/Y _4548_/A VPWR VGND sg13g2_o21ai_1
X_4476_ _4478_/C _4476_/A _4476_/B _4476_/C _4476_/D VPWR VGND sg13g2_nor4_1
X_3427_ _3427_/Y _3756_/A VPWR VGND sg13g2_inv_1
X_3358_ _3358_/Y _4448_/A _3359_/B VPWR VGND sg13g2_xnor2_1
X_3289_ _3290_/B _3289_/A _3289_/B VPWR VGND sg13g2_xnor2_1
X_5028_ _5028_/Y _5156_/A VPWR VGND sg13g2_inv_1
XFILLER_54_48 VPWR VGND sg13g2_decap_8
XFILLER_53_341 VPWR VGND sg13g2_fill_2
XFILLER_26_566 VPWR VGND sg13g2_decap_8
XFILLER_41_536 VPWR VGND sg13g2_decap_8
XFILLER_41_558 VPWR VGND sg13g2_fill_1
XFILLER_5_404 VPWR VGND sg13g2_decap_8
XFILLER_0_164 VPWR VGND sg13g2_decap_8
XFILLER_0_175 VPWR VGND sg13g2_fill_1
XFILLER_48_124 VPWR VGND sg13g2_decap_8
XFILLER_64_617 VPWR VGND sg13g2_fill_1
XFILLER_28_60 VPWR VGND sg13g2_decap_8
XFILLER_28_71 VPWR VGND sg13g2_decap_4
XFILLER_63_105 VPWR VGND sg13g2_fill_1
XFILLER_29_393 VPWR VGND sg13g2_decap_8
XFILLER_32_503 VPWR VGND sg13g2_decap_8
XFILLER_32_514 VPWR VGND sg13g2_fill_2
XFILLER_44_352 VPWR VGND sg13g2_fill_2
XFILLER_44_385 VPWR VGND sg13g2_decap_8
XFILLER_81_7 VPWR VGND sg13g2_decap_8
XFILLER_40_591 VPWR VGND sg13g2_decap_8
X_2660_ _2665_/A _3000_/B _2660_/B VPWR VGND sg13g2_nand2_1
XFILLER_8_275 VPWR VGND sg13g2_decap_8
X_2591_ _2591_/Y input2/X VPWR VGND sg13g2_inv_1
X_4330_ _5316_/D _4249_/A hold720/X _4335_/B VPWR VGND sg13g2_mux2_1
X_4261_ _4261_/Y _4261_/A _4280_/B VPWR VGND sg13g2_nand2_1
X_3212_ _3216_/A _4212_/A1 _2915_/C _3210_/Y VPWR VGND sg13g2_o21ai_1
X_4192_ _4475_/B _4192_/A _4192_/B _4192_/C _4192_/D VPWR VGND sg13g2_nor4_1
XFILLER_67_433 VPWR VGND sg13g2_decap_8
X_3143_ _3147_/C _3166_/A _3211_/B _3236_/B1 _2993_/A VPWR VGND sg13g2_a22oi_1
XFILLER_67_477 VPWR VGND sg13g2_decap_8
X_3074_ _3074_/Y _3074_/A _3074_/B VPWR VGND sg13g2_nor2_1
XFILLER_50_300 VPWR VGND sg13g2_decap_8
XFILLER_23_547 VPWR VGND sg13g2_decap_8
XFILLER_50_366 VPWR VGND sg13g2_decap_8
X_3976_ _3977_/B _4043_/A _3976_/B _3976_/C VPWR VGND sg13g2_nand3_1
XFILLER_50_399 VPWR VGND sg13g2_decap_8
X_2927_ _2930_/B _5368_/Q _2927_/A2 _3534_/A2 _5304_/Q VPWR VGND sg13g2_a22oi_1
XFILLER_31_591 VPWR VGND sg13g2_decap_8
X_2858_ _3027_/B _4494_/B _3704_/A VPWR VGND sg13g2_and2_1
X_2789_ _2789_/Y _2789_/A _2941_/B VPWR VGND sg13g2_nor2_1
X_4528_ _4528_/Y _5438_/A _4619_/B VPWR VGND sg13g2_nand2b_1
X_4459_ _4465_/B _4459_/A1 _3786_/B _3326_/Y VPWR VGND sg13g2_o21ai_1
XFILLER_58_400 VPWR VGND sg13g2_decap_8
XFILLER_58_466 VPWR VGND sg13g2_decap_8
XFILLER_45_105 VPWR VGND sg13g2_decap_4
XFILLER_58_477 VPWR VGND sg13g2_fill_2
XFILLER_45_138 VPWR VGND sg13g2_decap_4
XFILLER_41_311 VPWR VGND sg13g2_decap_8
XFILLER_53_171 VPWR VGND sg13g2_decap_8
XFILLER_14_73 VPWR VGND sg13g2_decap_8
XFILLER_49_433 VPWR VGND sg13g2_decap_8
XFILLER_37_606 VPWR VGND sg13g2_fill_1
XFILLER_76_230 VPWR VGND sg13g2_decap_8
XFILLER_17_330 VPWR VGND sg13g2_fill_1
XFILLER_76_296 VPWR VGND sg13g2_decap_8
XFILLER_17_341 VPWR VGND sg13g2_decap_8
XFILLER_72_491 VPWR VGND sg13g2_decap_8
XFILLER_55_91 VPWR VGND sg13g2_fill_1
X_3830_ _3830_/Y _4001_/B2 _4448_/A _3763_/B _3936_/A VPWR VGND sg13g2_a22oi_1
X_3761_ _4451_/A _3763_/D VPWR VGND sg13g2_inv_1
X_2712_ _2712_/Y _2723_/C _2723_/B VPWR VGND sg13g2_nor2_1
XFILLER_9_551 VPWR VGND sg13g2_decap_8
X_3692_ _3693_/B _5259_/Q _3692_/A2 _3691_/Y VPWR VGND sg13g2_o21ai_1
X_5431_ _5431_/Q _5432_/CLK _5431_/D _5171_/Y VPWR VGND sg13g2_dfrbpq_1
X_2643_ _2999_/B _2653_/B _2678_/B VPWR VGND sg13g2_or2_1
X_5362_ _5362_/Q clkload9/A _5362_/D _5102_/Y VPWR VGND sg13g2_dfrbpq_1
X_2574_ _4724_/A _2574_/A VPWR VGND sg13g2_inv_1
X_4313_ _5331_/D _4353_/A hold764/X _4317_/S VPWR VGND sg13g2_mux2_1
X_5293_ _5293_/Q clkload3/A _5293_/D _5033_/Y VPWR VGND sg13g2_dfrbpq_1
X_4244_ _5385_/D hold672/X _3908_/X _4249_/B VPWR VGND sg13g2_mux2_1
X_4175_ _4175_/Y _2597_/Y _4176_/A1 _4177_/A2 VPWR VGND sg13g2_a21oi_1
X_3126_ _3127_/C _3126_/A _3126_/B _3126_/C _3126_/D VPWR VGND sg13g2_nand4_1
XFILLER_55_447 VPWR VGND sg13g2_fill_1
X_3057_ _3057_/Y _3057_/A _4185_/B _3057_/C VPWR VGND sg13g2_nand3_1
XFILLER_70_406 VPWR VGND sg13g2_decap_8
XFILLER_42_119 VPWR VGND sg13g2_decap_8
XFILLER_23_344 VPWR VGND sg13g2_decap_8
XFILLER_51_642 VPWR VGND sg13g2_decap_8
XFILLER_50_152 VPWR VGND sg13g2_decap_8
X_3959_ _3992_/B _3991_/B _4017_/A _3999_/B VPWR VGND sg13g2_o21ai_1
Xfanout530 _5158_/A _5162_/A VPWR VGND sg13g2_buf_1
Xfanout541 _5148_/A _5092_/A VPWR VGND sg13g2_buf_1
XFILLER_76_24 VPWR VGND sg13g2_decap_8
Xfanout552 _5132_/A _5144_/A VPWR VGND sg13g2_buf_1
Xfanout563 _5076_/A fanout564/X VPWR VGND sg13g2_buf_1
Xfanout574 _2956_/B _4523_/B VPWR VGND sg13g2_buf_1
XFILLER_18_116 VPWR VGND sg13g2_fill_2
XFILLER_46_414 VPWR VGND sg13g2_decap_8
Xfanout585 _2716_/C input47/X VPWR VGND sg13g2_buf_1
Xfanout596 _4840_/A input39/X VPWR VGND sg13g2_buf_1
XFILLER_58_285 VPWR VGND sg13g2_fill_1
XFILLER_18_138 VPWR VGND sg13g2_fill_2
XFILLER_14_377 VPWR VGND sg13g2_fill_2
XFILLER_41_174 VPWR VGND sg13g2_decap_4
XFILLER_41_82 VPWR VGND sg13g2_decap_8
XFILLER_44_7 VPWR VGND sg13g2_decap_4
XFILLER_77_572 VPWR VGND sg13g2_decap_8
XFILLER_18_650 VPWR VGND sg13g2_fill_2
XFILLER_52_417 VPWR VGND sg13g2_decap_8
XFILLER_52_439 VPWR VGND sg13g2_fill_1
X_4931_ _4931_/Y _5095_/A VPWR VGND sg13g2_inv_1
XFILLER_33_642 VPWR VGND sg13g2_fill_1
X_4862_ _4862_/Y _4878_/A _4862_/B VPWR VGND sg13g2_nor2_1
XFILLER_20_303 VPWR VGND sg13g2_decap_8
X_3813_ _3813_/Y _3813_/A _3838_/B VPWR VGND sg13g2_nand2_1
XFILLER_20_336 VPWR VGND sg13g2_decap_8
X_4793_ _4795_/C _4793_/A _4808_/B VPWR VGND sg13g2_or2_1
X_3744_ _3744_/Y _3853_/B _3742_/Y _3743_/X VPWR VGND sg13g2_o21ai_1
X_3675_ _3678_/B _5192_/Q _3644_/B _3689_/B1 _5420_/Q VPWR VGND sg13g2_a22oi_1
X_5414_ _5414_/Q _5414_/CLK _5414_/D _5154_/Y VPWR VGND sg13g2_dfrbpq_1
Xoutput100 dmem_addr[11] _4561_/Y VPWR VGND sg13g2_buf_1
X_2626_ _4740_/A _5206_/Q VPWR VGND sg13g2_inv_1
Xoutput133 dmem_wdata[11] _5447_/A VPWR VGND sg13g2_buf_1
Xoutput122 dmem_addr[31] _4642_/X VPWR VGND sg13g2_buf_1
Xoutput111 dmem_addr[21] _4607_/Y VPWR VGND sg13g2_buf_1
X_5345_ _5345_/Q clkload7/A _5345_/D _5085_/Y VPWR VGND sg13g2_dfrbpq_1
Xoutput155 dmem_wdata[31] _5467_/A VPWR VGND sg13g2_buf_1
Xoutput166 imem_addr[11] _5204_/Q VPWR VGND sg13g2_buf_1
Xoutput177 imem_addr[21] _5214_/Q VPWR VGND sg13g2_buf_1
Xoutput144 dmem_wdata[21] _5457_/A VPWR VGND sg13g2_buf_1
X_2557_ _2557_/Y _2557_/A VPWR VGND sg13g2_inv_1
X_5276_ _5276_/Q _5434_/CLK _5276_/D _5016_/Y VPWR VGND sg13g2_dfrbpq_1
Xoutput188 imem_addr[31] _5224_/Q VPWR VGND sg13g2_buf_1
Xoutput199 io_wdata[11] _5447_/X VPWR VGND sg13g2_buf_1
X_4227_ _5399_/D hold841/X _4346_/A _4237_/S VPWR VGND sg13g2_mux2_1
XFILLER_28_414 VPWR VGND sg13g2_decap_8
XFILLER_28_425 VPWR VGND sg13g2_fill_1
XFILLER_28_458 VPWR VGND sg13g2_decap_8
X_4158_ _4159_/B _4158_/A _4158_/B VPWR VGND sg13g2_xnor2_1
XFILLER_68_594 VPWR VGND sg13g2_decap_8
X_4089_ _4089_/Y _3714_/B _4077_/Y _3823_/A VPWR VGND sg13g2_a21oi_1
X_3109_ _3109_/Y _3109_/A _3109_/B _3109_/C _3109_/D VPWR VGND sg13g2_nand4_1
XFILLER_70_214 VPWR VGND sg13g2_decap_8
XFILLER_70_203 VPWR VGND sg13g2_decap_4
XFILLER_23_130 VPWR VGND sg13g2_decap_8
XFILLER_11_303 VPWR VGND sg13g2_decap_8
XFILLER_7_329 VPWR VGND sg13g2_decap_8
XFILLER_66_509 VPWR VGND sg13g2_decap_8
XFILLER_19_414 VPWR VGND sg13g2_decap_8
Xfanout360 _4439_/D _3776_/A VPWR VGND sg13g2_buf_1
Xfanout371 _4436_/C _2939_/Y VPWR VGND sg13g2_buf_1
Xfanout382 _3838_/B _3858_/A VPWR VGND sg13g2_buf_1
Xfanout393 _4100_/A _2664_/X VPWR VGND sg13g2_buf_1
XFILLER_19_447 VPWR VGND sg13g2_decap_4
XFILLER_74_531 VPWR VGND sg13g2_decap_8
XFILLER_19_469 VPWR VGND sg13g2_decap_8
XFILLER_74_586 VPWR VGND sg13g2_decap_8
XFILLER_61_225 VPWR VGND sg13g2_fill_1
XFILLER_15_631 VPWR VGND sg13g2_decap_8
XFILLER_27_491 VPWR VGND sg13g2_fill_1
XFILLER_61_236 VPWR VGND sg13g2_decap_8
Xinput13 _2607_/A dmem_rdata[20] VPWR VGND sg13g2_buf_1
Xinput46 input46/X imem_data[21] VPWR VGND sg13g2_buf_1
Xinput35 _2574_/A imem_data[11] VPWR VGND sg13g2_buf_1
Xinput24 _2621_/A dmem_rdata[30] VPWR VGND sg13g2_buf_1
XFILLER_10_391 VPWR VGND sg13g2_fill_1
Xinput79 _2610_/A io_rdata[22] VPWR VGND sg13g2_buf_1
Xinput68 input68/X io_rdata[12] VPWR VGND sg13g2_buf_1
Xinput57 _2678_/B imem_data[31] VPWR VGND sg13g2_buf_1
Xhold819 hold819/X _5325_/Q VPWR VGND sg13g2_dlygate4sd3_1
Xhold808 hold808/X _5274_/Q VPWR VGND sg13g2_dlygate4sd3_1
XFILLER_6_362 VPWR VGND sg13g2_decap_8
X_3460_ _3460_/Y _3460_/A _3460_/B _3460_/C _3460_/D VPWR VGND sg13g2_nand4_1
XFILLER_42_4 VPWR VGND sg13g2_fill_2
X_3391_ _5451_/A _3387_/Y _3389_/Y _3390_/Y VPWR VGND sg13g2_a21oi_1
X_5130_ _5130_/Y _5162_/A VPWR VGND sg13g2_inv_1
X_5061_ _5061_/Y _5161_/A VPWR VGND sg13g2_inv_1
X_4012_ _4012_/Y _2612_/Y _4059_/A2 _4010_/Y _4011_/Y VPWR VGND sg13g2_a22oi_1
XFILLER_37_211 VPWR VGND sg13g2_decap_8
XFILLER_37_266 VPWR VGND sg13g2_decap_8
XFILLER_65_564 VPWR VGND sg13g2_decap_8
XFILLER_52_258 VPWR VGND sg13g2_decap_8
X_4914_ _4914_/Y _4914_/A _4913_/B VPWR VGND sg13g2_nor2b_1
XFILLER_80_556 VPWR VGND sg13g2_decap_8
XFILLER_21_645 VPWR VGND sg13g2_fill_2
X_4845_ _4846_/C _4845_/A _4845_/B _4845_/C _4845_/D VPWR VGND sg13g2_or4_1
XFILLER_60_280 VPWR VGND sg13g2_decap_8
X_4776_ _4777_/C _4846_/A _4808_/A VPWR VGND sg13g2_nand2_1
X_3727_ _3729_/B _4439_/D _3418_/B _3719_/Y _3725_/Y _3726_/Y VPWR VGND sg13g2_a221oi_1
X_3658_ _3658_/Y _3654_/B _3895_/A VPWR VGND sg13g2_nand2b_1
X_3589_ _3589_/Y _3589_/A _3679_/A VPWR VGND sg13g2_nand2_1
X_2609_ _2609_/Y _2609_/A VPWR VGND sg13g2_inv_1
X_5328_ _5328_/Q _5427_/CLK _5328_/D _5068_/Y VPWR VGND sg13g2_dfrbpq_1
XFILLER_0_549 VPWR VGND sg13g2_decap_8
X_5259_ _5259_/Q _5421_/CLK _5259_/D _4999_/Y VPWR VGND sg13g2_dfrbpq_1
XFILLER_28_233 VPWR VGND sg13g2_decap_8
XFILLER_28_266 VPWR VGND sg13g2_decap_4
Xclkbuf_2_2__f_clk clkbuf_leaf_9_clk/A clkbuf_0_clk/X VPWR VGND sg13g2_buf_16
XFILLER_56_597 VPWR VGND sg13g2_decap_8
XFILLER_43_236 VPWR VGND sg13g2_fill_1
XFILLER_71_578 VPWR VGND sg13g2_fill_1
XFILLER_24_483 VPWR VGND sg13g2_decap_8
XFILLER_51_291 VPWR VGND sg13g2_decap_8
XFILLER_8_627 VPWR VGND sg13g2_fill_2
XFILLER_7_104 VPWR VGND sg13g2_fill_1
XFILLER_11_177 VPWR VGND sg13g2_decap_4
XFILLER_79_634 VPWR VGND sg13g2_decap_8
XFILLER_79_612 VPWR VGND sg13g2_decap_8
XFILLER_78_133 VPWR VGND sg13g2_decap_8
XFILLER_47_542 VPWR VGND sg13g2_fill_2
XFILLER_47_553 VPWR VGND sg13g2_fill_2
XFILLER_47_597 VPWR VGND sg13g2_decap_8
XFILLER_34_236 VPWR VGND sg13g2_decap_8
XFILLER_62_556 VPWR VGND sg13g2_fill_2
XFILLER_15_450 VPWR VGND sg13g2_decap_4
X_2960_ _3057_/A _2960_/A _4095_/A VPWR VGND sg13g2_nor2_1
X_2891_ _3251_/A _2849_/Y _3270_/B _2848_/X VPWR VGND sg13g2_a21oi_1
XFILLER_30_464 VPWR VGND sg13g2_decap_8
X_4630_ _4633_/B _5463_/A _5462_/A _4630_/C VPWR VGND sg13g2_nor3_2
X_4561_ _4561_/Y _4561_/A _4561_/B VPWR VGND sg13g2_xnor2_1
Xhold616 _4414_/A _5243_/Q VPWR VGND sg13g2_dlygate4sd3_1
Xhold627 _4221_/A _5403_/Q VPWR VGND sg13g2_dlygate4sd3_1
X_4492_ _4495_/A _4499_/A _4524_/A VPWR VGND sg13g2_nand2_1
X_3512_ _3512_/Y _3512_/A _3512_/B _3512_/C _3512_/D VPWR VGND sg13g2_nand4_1
Xhold638 _2542_/A _5395_/Q VPWR VGND sg13g2_dlygate4sd3_1
Xhold649 _2548_/A _5373_/Q VPWR VGND sg13g2_dlygate4sd3_1
X_3443_ _3443_/Y _3443_/A _3443_/B VPWR VGND sg13g2_nor2_1
X_5113_ _5113_/Y _5166_/A VPWR VGND sg13g2_inv_1
X_3374_ _3417_/B _4749_/A _5450_/A _3392_/S VPWR VGND sg13g2_mux2_1
X_5044_ _5044_/Y _5076_/A VPWR VGND sg13g2_inv_1
XFILLER_38_597 VPWR VGND sg13g2_decap_8
XFILLER_65_372 VPWR VGND sg13g2_decap_8
XFILLER_65_361 VPWR VGND sg13g2_decap_4
XFILLER_53_578 VPWR VGND sg13g2_decap_8
XFILLER_43_39 VPWR VGND sg13g2_decap_8
X_4828_ _4831_/B _4828_/A _4828_/B VPWR VGND sg13g2_xnor2_1
XFILLER_21_497 VPWR VGND sg13g2_fill_2
X_4759_ _5207_/D _4814_/A hold875/X _4758_/Y VPWR VGND sg13g2_o21ai_1
XFILLER_68_25 VPWR VGND sg13g2_decap_8
XFILLER_76_626 VPWR VGND sg13g2_decap_4
XFILLER_75_103 VPWR VGND sg13g2_decap_8
XFILLER_29_542 VPWR VGND sg13g2_decap_8
XFILLER_29_597 VPWR VGND sg13g2_decap_8
XFILLER_56_383 VPWR VGND sg13g2_fill_1
XFILLER_16_225 VPWR VGND sg13g2_decap_8
XFILLER_71_320 VPWR VGND sg13g2_fill_2
XFILLER_16_269 VPWR VGND sg13g2_fill_1
XFILLER_17_95 VPWR VGND sg13g2_decap_8
XFILLER_44_589 VPWR VGND sg13g2_decap_8
XFILLER_8_479 VPWR VGND sg13g2_decap_8
XFILLER_3_151 VPWR VGND sg13g2_decap_4
XFILLER_79_431 VPWR VGND sg13g2_fill_1
X_3090_ _3090_/Y _2592_/Y _4217_/A1 _4195_/A2 VPWR VGND sg13g2_a21oi_1
XFILLER_66_147 VPWR VGND sg13g2_decap_8
XFILLER_35_534 VPWR VGND sg13g2_fill_2
XFILLER_81_139 VPWR VGND sg13g2_decap_4
XFILLER_62_342 VPWR VGND sg13g2_fill_1
X_3992_ _4008_/A _4088_/B _3992_/B _3992_/C VPWR VGND sg13g2_nand3_1
XFILLER_50_537 VPWR VGND sg13g2_decap_8
X_2943_ _2943_/Y _5431_/Q _3397_/B _3399_/B1 _5399_/Q _2940_/Y VPWR VGND sg13g2_a221oi_1
X_2874_ _2874_/Y _5231_/Q _3365_/A2 _3671_/B1 VPWR VGND sg13g2_a21oi_1
X_4613_ _4623_/D _5459_/A _4614_/B VPWR VGND sg13g2_nand2b_1
X_4544_ _4544_/Y _4676_/A _4543_/A _4543_/Y VPWR VGND sg13g2_o21ai_1
X_4475_ _4479_/D _4475_/A _4475_/B VPWR VGND sg13g2_nand2_1
X_3426_ _3426_/Y _3426_/A _3426_/B _3426_/C _3426_/D VPWR VGND sg13g2_nand4_1
X_3357_ _3357_/Y _3764_/A _3359_/B VPWR VGND sg13g2_nor2_1
XFILLER_58_637 VPWR VGND sg13g2_decap_8
XFILLER_45_309 VPWR VGND sg13g2_fill_1
X_5027_ _5027_/Y _5162_/A VPWR VGND sg13g2_inv_1
X_3288_ _5425_/D hold770/X _4278_/A _4518_/S VPWR VGND sg13g2_mux2_1
XFILLER_54_38 VPWR VGND sg13g2_fill_1
XFILLER_53_320 VPWR VGND sg13g2_decap_8
XFILLER_41_504 VPWR VGND sg13g2_decap_8
XFILLER_70_59 VPWR VGND sg13g2_decap_8
XFILLER_5_438 VPWR VGND sg13g2_decap_8
Xrebuffer598 _5448_/A _4568_/A VPWR VGND sg13g2_buf_1
XFILLER_5_449 VPWR VGND sg13g2_fill_1
XFILLER_1_611 VPWR VGND sg13g2_decap_8
XFILLER_0_187 VPWR VGND sg13g2_decap_8
XFILLER_76_423 VPWR VGND sg13g2_decap_4
XFILLER_29_361 VPWR VGND sg13g2_decap_8
XFILLER_63_117 VPWR VGND sg13g2_decap_8
XFILLER_17_534 VPWR VGND sg13g2_decap_4
XFILLER_44_331 VPWR VGND sg13g2_decap_8
XFILLER_17_578 VPWR VGND sg13g2_decap_8
XFILLER_72_651 VPWR VGND sg13g2_fill_1
XFILLER_32_548 VPWR VGND sg13g2_fill_1
XFILLER_71_194 VPWR VGND sg13g2_decap_8
XFILLER_40_581 VPWR VGND sg13g2_fill_1
XFILLER_8_243 VPWR VGND sg13g2_fill_1
XFILLER_74_7 VPWR VGND sg13g2_fill_1
XFILLER_8_265 VPWR VGND sg13g2_decap_4
X_2590_ _2590_/Y _2590_/A VPWR VGND sg13g2_inv_1
XFILLER_4_482 VPWR VGND sg13g2_decap_8
X_4260_ _5373_/D _3368_/A _4276_/B _4259_/Y VPWR VGND sg13g2_o21ai_1
X_4191_ _4192_/D _4433_/A _4184_/Y _4190_/Y VPWR VGND sg13g2_a21o_1
X_3211_ _3211_/Y _3233_/A _3211_/B VPWR VGND sg13g2_nand2_1
X_3142_ _3147_/B _4207_/A _3142_/B VPWR VGND sg13g2_or2_1
X_3073_ _3074_/B _3073_/A _3097_/B VPWR VGND sg13g2_nor2_1
X_3975_ _3976_/C _3771_/B _4043_/B _3771_/A VPWR VGND sg13g2_o21ai_1
XFILLER_62_194 VPWR VGND sg13g2_decap_4
X_2926_ _2930_/C _5240_/Q _2926_/B VPWR VGND sg13g2_nand2_1
X_2857_ _3027_/A _2974_/B VPWR VGND sg13g2_inv_1
X_2788_ _2796_/A _3166_/A VPWR VGND sg13g2_inv_1
X_4527_ _4529_/B _4644_/A _5438_/A _4641_/A VPWR VGND sg13g2_mux2_1
X_4458_ _4458_/Y _4458_/A _4465_/A VPWR VGND sg13g2_nor2_1
XFILLER_49_49 VPWR VGND sg13g2_decap_8
X_3409_ _3409_/Y _3411_/A _3409_/B _3411_/C VPWR VGND sg13g2_nor3_1
X_4389_ _5267_/D _4353_/A hold776/X _4393_/S VPWR VGND sg13g2_mux2_1
XFILLER_65_37 VPWR VGND sg13g2_decap_4
XFILLER_26_353 VPWR VGND sg13g2_decap_8
XFILLER_26_375 VPWR VGND sg13g2_decap_4
XFILLER_26_397 VPWR VGND sg13g2_fill_2
XFILLER_81_25 VPWR VGND sg13g2_fill_2
XFILLER_81_14 VPWR VGND sg13g2_decap_8
XFILLER_14_559 VPWR VGND sg13g2_decap_8
XFILLER_14_52 VPWR VGND sg13g2_decap_8
XFILLER_5_213 VPWR VGND sg13g2_decap_8
XFILLER_1_496 VPWR VGND sg13g2_fill_1
XFILLER_39_93 VPWR VGND sg13g2_decap_4
XFILLER_76_275 VPWR VGND sg13g2_decap_8
XFILLER_76_253 VPWR VGND sg13g2_fill_2
XFILLER_64_437 VPWR VGND sg13g2_decap_4
XFILLER_60_621 VPWR VGND sg13g2_fill_1
XFILLER_32_345 VPWR VGND sg13g2_decap_4
XFILLER_20_507 VPWR VGND sg13g2_fill_1
X_3760_ _3763_/D _4445_/A _4446_/B _3879_/B _4445_/B VPWR VGND sg13g2_nand4_1
XFILLER_13_581 VPWR VGND sg13g2_fill_1
X_2711_ _2711_/Y _2723_/C _2724_/A _2723_/B VPWR VGND sg13g2_nand3b_1
XFILLER_9_530 VPWR VGND sg13g2_decap_8
X_5430_ _5430_/Q _5430_/CLK _5430_/D _5170_/Y VPWR VGND sg13g2_dfrbpq_1
X_3691_ _3691_/Y _3691_/A _3691_/B _3691_/C _3691_/D VPWR VGND sg13g2_nand4_1
XFILLER_72_4 VPWR VGND sg13g2_decap_8
X_2642_ _2955_/B _2653_/B _2678_/B VPWR VGND sg13g2_nor2_1
X_5361_ _5361_/Q _5427_/CLK _5361_/D _5101_/Y VPWR VGND sg13g2_dfrbpq_1
X_2573_ _4742_/A _2573_/A VPWR VGND sg13g2_inv_1
X_5292_ _5292_/Q clkload3/A _5292_/D _5032_/Y VPWR VGND sg13g2_dfrbpq_1
X_4312_ _5332_/D _4351_/A hold831/X _4312_/S VPWR VGND sg13g2_mux2_1
X_4243_ _5386_/D hold758/X _3890_/Y _4247_/S VPWR VGND sg13g2_mux2_1
X_4174_ _4481_/D _4174_/A _4174_/B _4174_/C _4174_/D VPWR VGND sg13g2_nand4_1
XFILLER_27_117 VPWR VGND sg13g2_decap_4
X_3125_ _3127_/B _3239_/A _3125_/B VPWR VGND sg13g2_nor2_1
XFILLER_55_415 VPWR VGND sg13g2_decap_4
X_3056_ _3056_/Y _3056_/A _4185_/B VPWR VGND sg13g2_nor2b_1
XFILLER_50_120 VPWR VGND sg13g2_fill_2
X_3958_ _4017_/A _3958_/A _3957_/X VPWR VGND sg13g2_nor2b_1
X_3889_ _3889_/Y _3889_/A _3889_/B VPWR VGND sg13g2_nand2_1
X_2909_ _3225_/B _3044_/D VPWR VGND sg13g2_inv_1
XFILLER_4_7 VPWR VGND sg13g2_decap_8
Xfanout520 _2817_/C _2689_/Y VPWR VGND sg13g2_buf_1
Xfanout531 _5159_/A _5162_/A VPWR VGND sg13g2_buf_1
Xfanout542 _5092_/A fanout545/X VPWR VGND sg13g2_buf_1
Xfanout553 _5112_/A _5144_/A VPWR VGND sg13g2_buf_1
Xfanout564 fanout564/X fanout565/X VPWR VGND sg13g2_buf_1
Xfanout575 _2704_/B _3589_/A VPWR VGND sg13g2_buf_1
XFILLER_19_618 VPWR VGND sg13g2_decap_8
Xfanout586 _2723_/C _2716_/A VPWR VGND sg13g2_buf_1
Xfanout597 _4807_/A input39/X VPWR VGND sg13g2_buf_1
XFILLER_18_128 VPWR VGND sg13g2_fill_1
XFILLER_14_312 VPWR VGND sg13g2_decap_8
XFILLER_26_172 VPWR VGND sg13g2_decap_8
XFILLER_73_289 VPWR VGND sg13g2_fill_1
XFILLER_25_51 VPWR VGND sg13g2_decap_4
XFILLER_42_632 VPWR VGND sg13g2_decap_8
XFILLER_41_164 VPWR VGND sg13g2_fill_1
XFILLER_10_562 VPWR VGND sg13g2_decap_8
XFILLER_41_61 VPWR VGND sg13g2_decap_8
XFILLER_6_544 VPWR VGND sg13g2_decap_8
XFILLER_69_518 VPWR VGND sg13g2_decap_8
XFILLER_37_7 VPWR VGND sg13g2_fill_1
XFILLER_2_11 VPWR VGND sg13g2_fill_2
XFILLER_77_551 VPWR VGND sg13g2_decap_8
XFILLER_77_562 VPWR VGND sg13g2_fill_1
XFILLER_37_459 VPWR VGND sg13g2_fill_1
XFILLER_17_172 VPWR VGND sg13g2_decap_8
XFILLER_45_481 VPWR VGND sg13g2_decap_8
X_4930_ _4930_/Y _5095_/A VPWR VGND sg13g2_inv_1
X_4861_ _4861_/X _4861_/A _4867_/B VPWR VGND sg13g2_xor2_1
X_3812_ _4479_/A _3812_/A _3812_/B _3812_/C _3812_/D VPWR VGND sg13g2_nand4_1
XFILLER_60_473 VPWR VGND sg13g2_decap_8
X_4792_ _4809_/B _4774_/B _4784_/B _4831_/A VPWR VGND sg13g2_a21o_1
X_3743_ _3743_/X _3681_/B _3697_/A _3834_/A VPWR VGND sg13g2_a21o_1
X_3674_ _3678_/A _5324_/Q _3674_/A2 _3674_/B1 _5292_/Q VPWR VGND sg13g2_a22oi_1
X_5413_ _5413_/Q clkload5/A _5413_/D _5153_/Y VPWR VGND sg13g2_dfrbpq_1
Xoutput101 dmem_addr[12] _4565_/Y VPWR VGND sg13g2_buf_1
X_2625_ _4719_/C _2625_/A VPWR VGND sg13g2_inv_1
XFILLER_63_0 VPWR VGND sg13g2_decap_8
X_5344_ _5344_/Q clkload8/A _5344_/D _5084_/Y VPWR VGND sg13g2_dfrbpq_1
Xoutput134 dmem_wdata[12] _5448_/A VPWR VGND sg13g2_buf_1
Xoutput123 dmem_addr[3] _4534_/Y VPWR VGND sg13g2_buf_1
Xoutput112 dmem_addr[22] _4612_/Y VPWR VGND sg13g2_buf_1
Xoutput156 dmem_wdata[3] _5439_/A VPWR VGND sg13g2_buf_1
Xoutput167 imem_addr[12] _5205_/Q VPWR VGND sg13g2_buf_1
Xoutput145 dmem_wdata[22] _5458_/A VPWR VGND sg13g2_buf_1
X_2556_ _2556_/Y _2556_/A VPWR VGND sg13g2_inv_1
X_5275_ _5275_/Q _5435_/CLK _5275_/D _5015_/Y VPWR VGND sg13g2_dfrbpq_1
Xoutput178 imem_addr[22] _5215_/Q VPWR VGND sg13g2_buf_1
Xoutput189 imem_addr[3] _5196_/Q VPWR VGND sg13g2_buf_1
X_4226_ _5400_/D hold833/X _3136_/Y _4237_/S VPWR VGND sg13g2_mux2_1
X_4157_ _4174_/A _3721_/C _4157_/B VPWR VGND sg13g2_nand2b_1
XFILLER_68_551 VPWR VGND sg13g2_decap_8
X_3108_ _3109_/D _4133_/A _3097_/Y _3100_/B _4433_/A VPWR VGND sg13g2_a22oi_1
X_4088_ _4103_/A _4087_/Y _4088_/B _4088_/C VPWR VGND sg13g2_nand3b_1
XFILLER_55_267 VPWR VGND sg13g2_decap_8
XFILLER_15_109 VPWR VGND sg13g2_decap_8
X_3039_ _3157_/A _3182_/A _3181_/B VPWR VGND sg13g2_nor2_1
XFILLER_24_632 VPWR VGND sg13g2_decap_4
XFILLER_51_473 VPWR VGND sg13g2_fill_2
XFILLER_62_49 VPWR VGND sg13g2_fill_2
XFILLER_51_484 VPWR VGND sg13g2_decap_8
XFILLER_11_359 VPWR VGND sg13g2_decap_8
XFILLER_11_75 VPWR VGND sg13g2_decap_8
XFILLER_3_569 VPWR VGND sg13g2_fill_2
Xfanout350 _5465_/A _4639_/B VPWR VGND sg13g2_buf_1
XFILLER_78_348 VPWR VGND sg13g2_fill_1
Xfanout361 _3765_/A _3326_/Y VPWR VGND sg13g2_buf_1
Xfanout372 _2986_/A _4439_/B VPWR VGND sg13g2_buf_1
Xfanout383 _3858_/A _2680_/Y VPWR VGND sg13g2_buf_1
XFILLER_19_426 VPWR VGND sg13g2_fill_2
XFILLER_46_223 VPWR VGND sg13g2_decap_4
Xfanout394 _3064_/A _4009_/B1 VPWR VGND sg13g2_buf_1
XFILLER_27_470 VPWR VGND sg13g2_fill_1
XFILLER_34_418 VPWR VGND sg13g2_decap_8
XFILLER_61_204 VPWR VGND sg13g2_decap_8
XFILLER_42_440 VPWR VGND sg13g2_decap_8
XFILLER_42_462 VPWR VGND sg13g2_decap_8
XFILLER_14_175 VPWR VGND sg13g2_fill_2
XFILLER_42_484 VPWR VGND sg13g2_decap_8
XFILLER_52_71 VPWR VGND sg13g2_fill_2
Xinput36 _4736_/A imem_data[12] VPWR VGND sg13g2_buf_1
Xinput25 _2622_/A dmem_rdata[31] VPWR VGND sg13g2_buf_1
Xinput14 _2609_/A dmem_rdata[21] VPWR VGND sg13g2_buf_1
Xinput69 _2594_/A io_rdata[13] VPWR VGND sg13g2_buf_1
Xinput58 _4652_/A imem_data[3] VPWR VGND sg13g2_buf_1
Xinput47 input47/X imem_data[22] VPWR VGND sg13g2_buf_1
Xhold809 hold809/X _5396_/Q VPWR VGND sg13g2_dlygate4sd3_1
X_3390_ _3390_/Y _5246_/Q _3401_/A2 _3398_/B1 VPWR VGND sg13g2_a21oi_1
XFILLER_69_304 VPWR VGND sg13g2_decap_8
X_5060_ _5060_/Y _5159_/A VPWR VGND sg13g2_inv_1
X_4011_ _4011_/Y _2716_/C _3064_/A _4059_/A2 VPWR VGND sg13g2_a21oi_1
XFILLER_77_392 VPWR VGND sg13g2_fill_1
XFILLER_65_543 VPWR VGND sg13g2_decap_8
XFILLER_25_429 VPWR VGND sg13g2_decap_8
XFILLER_80_502 VPWR VGND sg13g2_fill_1
XFILLER_52_237 VPWR VGND sg13g2_decap_8
X_4913_ _4915_/B _4913_/A _4913_/B VPWR VGND sg13g2_xnor2_1
XFILLER_33_451 VPWR VGND sg13g2_fill_2
X_4844_ _4851_/B _4856_/B _4844_/B VPWR VGND sg13g2_xor2_1
XFILLER_20_145 VPWR VGND sg13g2_fill_2
X_4775_ _4793_/A _4846_/A _4808_/A VPWR VGND sg13g2_or2_1
X_3726_ _3726_/Y _3726_/A _3726_/B VPWR VGND sg13g2_nor2_1
X_3657_ _3657_/Y _3868_/A _3739_/C VPWR VGND sg13g2_nor2_1
X_3588_ _4445_/A _3587_/A _3588_/B VPWR VGND sg13g2_nand2b_1
X_2608_ _2608_/Y _2608_/A VPWR VGND sg13g2_inv_1
XFILLER_0_528 VPWR VGND sg13g2_decap_8
X_5327_ _5327_/Q _5427_/CLK _5327_/D _5067_/Y VPWR VGND sg13g2_dfrbpq_1
X_2539_ _2539_/Y _2539_/A VPWR VGND sg13g2_inv_1
X_5258_ _5258_/Q clkload0/A _5258_/D _4998_/Y VPWR VGND sg13g2_dfrbpq_1
X_5189_ _5189_/Q clkload3/A _5189_/D _4929_/Y VPWR VGND sg13g2_dfrbpq_1
X_4209_ _4209_/Y _4209_/A1 _4441_/D _4209_/B1 _4440_/D VPWR VGND sg13g2_a22oi_1
XFILLER_56_565 VPWR VGND sg13g2_decap_8
XFILLER_71_513 VPWR VGND sg13g2_decap_8
XFILLER_71_557 VPWR VGND sg13g2_decap_8
XFILLER_12_602 VPWR VGND sg13g2_decap_8
XFILLER_24_462 VPWR VGND sg13g2_fill_1
XFILLER_11_123 VPWR VGND sg13g2_fill_2
XFILLER_51_270 VPWR VGND sg13g2_decap_8
XFILLER_8_606 VPWR VGND sg13g2_decap_8
XFILLER_22_41 VPWR VGND sg13g2_decap_8
XFILLER_8_639 VPWR VGND sg13g2_decap_4
XFILLER_22_96 VPWR VGND sg13g2_decap_8
XFILLER_3_333 VPWR VGND sg13g2_decap_4
XFILLER_3_355 VPWR VGND sg13g2_decap_4
XFILLER_78_178 VPWR VGND sg13g2_decap_8
XFILLER_14_9 VPWR VGND sg13g2_fill_1
XFILLER_19_212 VPWR VGND sg13g2_decap_4
XFILLER_47_521 VPWR VGND sg13g2_decap_8
XFILLER_78_189 VPWR VGND sg13g2_fill_1
XFILLER_59_392 VPWR VGND sg13g2_decap_8
XFILLER_19_256 VPWR VGND sg13g2_decap_8
XFILLER_47_576 VPWR VGND sg13g2_decap_8
XFILLER_74_373 VPWR VGND sg13g2_decap_8
XFILLER_62_502 VPWR VGND sg13g2_decap_8
XFILLER_42_281 VPWR VGND sg13g2_decap_8
X_2890_ _3270_/B _2867_/Y _2889_/Y _2869_/A VPWR VGND sg13g2_o21ai_1
XFILLER_30_443 VPWR VGND sg13g2_decap_8
X_4560_ _4561_/B _4559_/B _5447_/A _4559_/Y VPWR VGND sg13g2_o21ai_1
Xhold617 _4304_/A _5339_/Q VPWR VGND sg13g2_dlygate4sd3_1
X_4491_ _4491_/Y _2636_/B _4486_/Y _4488_/Y _4490_/Y _4487_/Y VPWR VGND sg13g2_a221oi_1
X_3511_ _3512_/D _5345_/Q _3683_/B1 _3684_/B1 _5281_/Q VPWR VGND sg13g2_a22oi_1
XFILLER_6_171 VPWR VGND sg13g2_decap_8
Xhold628 hold628/X _5230_/Q VPWR VGND sg13g2_dlygate4sd3_1
Xhold639 _2552_/A _5363_/Q VPWR VGND sg13g2_dlygate4sd3_1
X_3442_ _3442_/X _3442_/A _3442_/B VPWR VGND sg13g2_or2_1
X_3373_ _5450_/A _3369_/Y _3371_/Y _3372_/Y VPWR VGND sg13g2_a21oi_1
X_5112_ _5112_/Y _5112_/A VPWR VGND sg13g2_inv_1
X_5043_ _5043_/Y _5172_/A VPWR VGND sg13g2_inv_1
XFILLER_57_329 VPWR VGND sg13g2_decap_4
XFILLER_25_215 VPWR VGND sg13g2_fill_1
XFILLER_38_576 VPWR VGND sg13g2_decap_8
XFILLER_53_557 VPWR VGND sg13g2_decap_8
XFILLER_53_535 VPWR VGND sg13g2_fill_2
XFILLER_21_421 VPWR VGND sg13g2_fill_1
X_4827_ _4856_/C _5213_/Q _5214_/Q _5215_/Q _4827_/D VPWR VGND sg13g2_and4_1
X_4758_ _4758_/Y _4814_/A _4758_/B _4758_/C VPWR VGND sg13g2_nand3_1
X_4689_ _4690_/B _4679_/B _4681_/B _4677_/Y VPWR VGND sg13g2_a21oi_1
X_3709_ _3709_/Y _4019_/B _4019_/C _3708_/Y VPWR VGND sg13g2_a21oi_1
XFILLER_29_521 VPWR VGND sg13g2_decap_8
XFILLER_48_329 VPWR VGND sg13g2_decap_8
XFILLER_29_532 VPWR VGND sg13g2_fill_1
XFILLER_75_148 VPWR VGND sg13g2_fill_2
XFILLER_16_204 VPWR VGND sg13g2_decap_8
XFILLER_17_74 VPWR VGND sg13g2_decap_8
XFILLER_44_568 VPWR VGND sg13g2_decap_8
XFILLER_33_40 VPWR VGND sg13g2_decap_4
XFILLER_8_436 VPWR VGND sg13g2_fill_1
XFILLER_8_425 VPWR VGND sg13g2_decap_8
XFILLER_4_631 VPWR VGND sg13g2_decap_8
XFILLER_3_174 VPWR VGND sg13g2_fill_1
XFILLER_3_185 VPWR VGND sg13g2_decap_4
XFILLER_79_421 VPWR VGND sg13g2_fill_2
XFILLER_66_104 VPWR VGND sg13g2_decap_4
XFILLER_58_81 VPWR VGND sg13g2_decap_8
XFILLER_35_502 VPWR VGND sg13g2_decap_8
XFILLER_47_362 VPWR VGND sg13g2_decap_4
XFILLER_81_129 VPWR VGND sg13g2_fill_2
XFILLER_74_192 VPWR VGND sg13g2_fill_2
XFILLER_50_516 VPWR VGND sg13g2_decap_8
X_3991_ _3992_/C _3999_/B _3991_/B _4017_/A VPWR VGND sg13g2_or3_1
XFILLER_62_354 VPWR VGND sg13g2_decap_8
X_2942_ _2942_/Y _5271_/Q _3400_/A2 _3400_/B1 _5335_/Q _2941_/Y VPWR VGND sg13g2_a221oi_1
X_2873_ _2873_/Y _5327_/Q _3004_/A2 _3003_/B1 _5263_/Q _2872_/Y VPWR VGND sg13g2_a221oi_1
X_4612_ _4612_/Y _4623_/C _4610_/Y _4611_/Y VPWR VGND sg13g2_o21ai_1
X_4543_ _4543_/Y _4543_/A _4543_/B VPWR VGND sg13g2_nand2_1
X_4474_ _4476_/D _4474_/A _4474_/B _4474_/C _4474_/D VPWR VGND sg13g2_or4_1
X_3425_ _3426_/D _5381_/Q _3581_/B _3668_/A2 _5349_/Q VPWR VGND sg13g2_a22oi_1
X_3356_ _3359_/B _3679_/A _5466_/A VPWR VGND sg13g2_nor2_1
XFILLER_58_616 VPWR VGND sg13g2_fill_2
X_3287_ _4278_/A _2582_/Y _3222_/B _3285_/Y _3286_/Y VPWR VGND sg13g2_a22oi_1
XFILLER_38_340 VPWR VGND sg13g2_decap_4
X_5026_ _5026_/Y _5154_/A VPWR VGND sg13g2_inv_1
XFILLER_26_502 VPWR VGND sg13g2_fill_1
XFILLER_26_535 VPWR VGND sg13g2_decap_4
XFILLER_53_343 VPWR VGND sg13g2_fill_1
XFILLER_53_387 VPWR VGND sg13g2_decap_4
XFILLER_70_27 VPWR VGND sg13g2_decap_8
Xrebuffer599 _4568_/A _2727_/Y VPWR VGND sg13g2_buf_2
XFILLER_79_14 VPWR VGND sg13g2_decap_4
XFILLER_1_645 VPWR VGND sg13g2_decap_8
XFILLER_49_605 VPWR VGND sg13g2_decap_8
XFILLER_48_159 VPWR VGND sg13g2_decap_8
XFILLER_76_457 VPWR VGND sg13g2_decap_8
XFILLER_17_513 VPWR VGND sg13g2_decap_8
XFILLER_29_340 VPWR VGND sg13g2_decap_8
XFILLER_56_170 VPWR VGND sg13g2_decap_8
XFILLER_32_527 VPWR VGND sg13g2_decap_8
XFILLER_32_538 VPWR VGND sg13g2_fill_1
XFILLER_71_184 VPWR VGND sg13g2_decap_4
XFILLER_44_72 VPWR VGND sg13g2_fill_1
XFILLER_8_211 VPWR VGND sg13g2_decap_8
XFILLER_60_82 VPWR VGND sg13g2_fill_2
XFILLER_60_71 VPWR VGND sg13g2_decap_8
XFILLER_5_44 VPWR VGND sg13g2_decap_8
X_4190_ _4190_/Y _4207_/A _4184_/Y _4183_/Y VPWR VGND sg13g2_o21ai_1
X_3210_ _3210_/Y _3210_/A _3210_/B _3210_/C VPWR VGND sg13g2_nand3_1
X_3141_ _3147_/A _3144_/A _3023_/A _4094_/B1 VPWR VGND sg13g2_o21ai_1
X_3072_ _3072_/Y _3018_/Y _3096_/B VPWR VGND sg13g2_nand2b_1
XFILLER_63_641 VPWR VGND sg13g2_fill_2
XFILLER_35_354 VPWR VGND sg13g2_decap_8
XFILLER_23_538 VPWR VGND sg13g2_decap_4
XFILLER_62_173 VPWR VGND sg13g2_decap_8
XFILLER_50_335 VPWR VGND sg13g2_decap_8
X_3974_ _4043_/B _4450_/B _4450_/C _4092_/B VPWR VGND sg13g2_nand3_1
XFILLER_31_571 VPWR VGND sg13g2_fill_2
X_2925_ _2925_/Y _2925_/A _2925_/B _2925_/C VPWR VGND sg13g2_nand3_1
X_2856_ _2856_/Y _2852_/Y _2854_/Y _2855_/Y VPWR VGND sg13g2_a21oi_1
X_2787_ _2787_/Y _2783_/Y _2785_/Y _2786_/Y VPWR VGND sg13g2_a21oi_1
X_4526_ _4526_/X _4494_/B _5437_/A _4543_/A VPWR VGND sg13g2_mux2_1
XFILLER_49_28 VPWR VGND sg13g2_decap_8
X_4457_ _4465_/A _4483_/B _4457_/B VPWR VGND sg13g2_nand2_1
X_3408_ _3411_/C _3721_/A _3721_/B _3721_/C _4208_/B VPWR VGND sg13g2_nand4_1
X_4388_ _5268_/D _4351_/A hold767/X _4388_/S VPWR VGND sg13g2_mux2_1
X_3339_ _4463_/A _3679_/A _3765_/A _5467_/A VPWR VGND sg13g2_nor3_1
XFILLER_58_435 VPWR VGND sg13g2_decap_8
XFILLER_73_405 VPWR VGND sg13g2_decap_4
X_5009_ _5009_/Y _5175_/A VPWR VGND sg13g2_inv_1
XFILLER_14_538 VPWR VGND sg13g2_decap_8
XFILLER_53_162 VPWR VGND sg13g2_decap_4
XFILLER_14_20 VPWR VGND sg13g2_fill_2
XFILLER_81_59 VPWR VGND sg13g2_decap_8
XFILLER_30_30 VPWR VGND sg13g2_decap_8
XFILLER_5_247 VPWR VGND sg13g2_decap_8
XFILLER_30_85 VPWR VGND sg13g2_decap_8
XFILLER_30_96 VPWR VGND sg13g2_fill_1
XFILLER_1_475 VPWR VGND sg13g2_decap_8
XFILLER_49_424 VPWR VGND sg13g2_decap_4
XFILLER_64_416 VPWR VGND sg13g2_fill_1
XFILLER_55_82 VPWR VGND sg13g2_decap_8
XFILLER_32_368 VPWR VGND sg13g2_fill_1
X_2710_ _2710_/X _2724_/A _2710_/B VPWR VGND sg13g2_and2_1
X_3690_ _3691_/D _5355_/Q _3464_/B _2714_/B VPWR VGND sg13g2_a21oi_1
XFILLER_9_586 VPWR VGND sg13g2_fill_2
X_2641_ _2659_/B _2677_/A _4521_/A VPWR VGND sg13g2_nand2_1
XFILLER_65_4 VPWR VGND sg13g2_fill_2
X_5360_ _5360_/Q _5427_/CLK _5360_/D _5100_/Y VPWR VGND sg13g2_dfrbpq_1
X_2572_ _2572_/Y _4913_/A VPWR VGND sg13g2_inv_1
X_5291_ _5291_/Q _5421_/CLK _5291_/D _5031_/Y VPWR VGND sg13g2_dfrbpq_1
X_4311_ _5333_/D _3198_/Y hold838/X _4311_/S VPWR VGND sg13g2_mux2_1
X_4242_ _5387_/D hold803/X _3860_/Y _4249_/B VPWR VGND sg13g2_mux2_1
X_4173_ _4174_/D _4170_/X _4172_/Y _3721_/C VPWR VGND sg13g2_o21ai_1
XFILLER_67_232 VPWR VGND sg13g2_fill_1
XFILLER_28_619 VPWR VGND sg13g2_fill_2
X_3124_ _3126_/D _4436_/C _3211_/B _3233_/B _3022_/A _3121_/Y VPWR VGND sg13g2_a221oi_1
X_3055_ _4198_/A _3721_/A _3055_/B VPWR VGND sg13g2_nand2_1
XFILLER_67_298 VPWR VGND sg13g2_decap_8
XFILLER_55_438 VPWR VGND sg13g2_decap_8
XFILLER_50_110 VPWR VGND sg13g2_fill_1
X_3957_ _3957_/X _3564_/B _4113_/C _3573_/X VPWR VGND sg13g2_a21o_1
X_2908_ _3044_/D _3233_/A _3025_/B VPWR VGND sg13g2_xnor2_1
X_3888_ _3888_/Y _3838_/B _4481_/B _3064_/Y VPWR VGND sg13g2_o21ai_1
X_2839_ _3275_/A _2840_/A _2840_/B _2840_/C _2840_/D VPWR VGND sg13g2_and4_1
XFILLER_2_206 VPWR VGND sg13g2_fill_2
X_4509_ _5185_/D hold787/X _4012_/Y _4509_/S VPWR VGND sg13g2_mux2_1
Xfanout510 _2714_/B _2712_/Y VPWR VGND sg13g2_buf_2
Xfanout521 _3000_/B _2955_/B VPWR VGND sg13g2_buf_1
Xfanout532 _5162_/A fanout533/X VPWR VGND sg13g2_buf_1
Xfanout543 _5001_/A fanout545/X VPWR VGND sg13g2_buf_1
Xfanout554 _5144_/A fanout565/X VPWR VGND sg13g2_buf_1
Xfanout565 fanout565/X input97/X VPWR VGND sg13g2_buf_1
Xfanout576 _2895_/D _3589_/A VPWR VGND sg13g2_buf_1
Xfanout587 _2716_/A input46/X VPWR VGND sg13g2_buf_1
XFILLER_46_449 VPWR VGND sg13g2_decap_8
XFILLER_27_641 VPWR VGND sg13g2_fill_2
XFILLER_26_151 VPWR VGND sg13g2_decap_8
XFILLER_54_460 VPWR VGND sg13g2_decap_8
XFILLER_14_335 VPWR VGND sg13g2_decap_8
XFILLER_14_346 VPWR VGND sg13g2_fill_2
XFILLER_41_110 VPWR VGND sg13g2_fill_2
XFILLER_14_357 VPWR VGND sg13g2_fill_2
XFILLER_14_379 VPWR VGND sg13g2_fill_1
XFILLER_41_143 VPWR VGND sg13g2_decap_8
XFILLER_41_187 VPWR VGND sg13g2_decap_8
XFILLER_10_541 VPWR VGND sg13g2_decap_8
XFILLER_6_512 VPWR VGND sg13g2_decap_8
XFILLER_6_589 VPWR VGND sg13g2_decap_8
XFILLER_1_250 VPWR VGND sg13g2_fill_1
XFILLER_77_530 VPWR VGND sg13g2_decap_8
XFILLER_37_416 VPWR VGND sg13g2_decap_8
XFILLER_37_438 VPWR VGND sg13g2_decap_8
XFILLER_64_213 VPWR VGND sg13g2_decap_4
XFILLER_33_622 VPWR VGND sg13g2_decap_4
X_4860_ _4867_/B _4913_/A _4860_/B VPWR VGND sg13g2_xnor2_1
XFILLER_32_154 VPWR VGND sg13g2_decap_8
X_3811_ _3812_/D _3936_/A _3847_/B _3804_/B _4447_/A1 VPWR VGND sg13g2_a22oi_1
XFILLER_60_452 VPWR VGND sg13g2_decap_8
X_4791_ _4808_/C _4840_/A _4791_/B VPWR VGND sg13g2_xnor2_1
X_3742_ _3742_/Y _3829_/B _3855_/B VPWR VGND sg13g2_nand2b_1
X_3673_ _4445_/C _4449_/C VPWR VGND sg13g2_inv_1
X_5412_ _5412_/Q clkload6/A _5412_/D _5152_/Y VPWR VGND sg13g2_dfrbpq_1
X_2624_ _4719_/B _2624_/A VPWR VGND sg13g2_inv_1
X_5343_ _5343_/Q _5414_/CLK _5343_/D _5083_/Y VPWR VGND sg13g2_dfrbpq_1
Xoutput124 dmem_addr[4] _4538_/Y VPWR VGND sg13g2_buf_1
Xoutput113 dmem_addr[23] _4616_/Y VPWR VGND sg13g2_buf_1
Xoutput102 dmem_addr[13] _4574_/Y VPWR VGND sg13g2_buf_1
XFILLER_56_0 VPWR VGND sg13g2_decap_8
Xoutput157 dmem_wdata[4] _5440_/A VPWR VGND sg13g2_buf_1
Xoutput168 imem_addr[13] _5206_/Q VPWR VGND sg13g2_buf_1
Xoutput146 dmem_wdata[23] _5459_/A VPWR VGND sg13g2_buf_1
Xoutput135 dmem_wdata[13] _5449_/A VPWR VGND sg13g2_buf_1
X_2555_ _2555_/Y _2555_/A VPWR VGND sg13g2_inv_1
X_5274_ _5274_/Q _5434_/CLK _5274_/D _5014_/Y VPWR VGND sg13g2_dfrbpq_1
Xoutput179 imem_addr[23] _5216_/Q VPWR VGND sg13g2_buf_1
X_4225_ _5401_/D _2750_/A _4224_/B _4224_/Y VPWR VGND sg13g2_o21ai_1
X_4156_ _4157_/B _3375_/Y _4155_/Y _4153_/Y VPWR VGND sg13g2_o21ai_1
XFILLER_46_29 VPWR VGND sg13g2_decap_8
X_3107_ _3109_/C _4441_/A _3098_/X _3106_/Y VPWR VGND sg13g2_a21oi_1
X_4087_ _4087_/Y _4087_/A _4087_/B _4113_/C VPWR VGND sg13g2_nor3_1
X_3038_ _3181_/B _3201_/A _3228_/A _3037_/X VPWR VGND sg13g2_a21oi_1
XFILLER_36_493 VPWR VGND sg13g2_decap_8
XFILLER_51_463 VPWR VGND sg13g2_decap_4
XFILLER_11_338 VPWR VGND sg13g2_decap_8
X_4989_ _4989_/Y _5150_/A VPWR VGND sg13g2_inv_1
XFILLER_3_526 VPWR VGND sg13g2_fill_2
XFILLER_3_537 VPWR VGND sg13g2_fill_2
Xfanout340 _4434_/A _4440_/A VPWR VGND sg13g2_buf_1
Xfanout351 _3938_/B _3942_/A VPWR VGND sg13g2_buf_1
Xfanout362 _4206_/B _4441_/D VPWR VGND sg13g2_buf_1
Xfanout373 _4439_/B _2840_/Y VPWR VGND sg13g2_buf_1
Xfanout384 _2685_/B _4105_/A1 VPWR VGND sg13g2_buf_1
Xfanout395 _2666_/C _4009_/B1 VPWR VGND sg13g2_buf_1
XFILLER_59_585 VPWR VGND sg13g2_decap_8
XFILLER_46_257 VPWR VGND sg13g2_fill_1
XFILLER_36_62 VPWR VGND sg13g2_fill_1
XFILLER_14_154 VPWR VGND sg13g2_decap_8
XFILLER_30_614 VPWR VGND sg13g2_fill_2
XFILLER_52_94 VPWR VGND sg13g2_decap_8
Xinput37 _2573_/A imem_data[13] VPWR VGND sg13g2_buf_1
Xinput26 _2584_/A dmem_rdata[3] VPWR VGND sg13g2_buf_1
Xinput15 _2612_/A dmem_rdata[22] VPWR VGND sg13g2_buf_1
Xinput59 _2576_/A imem_data[4] VPWR VGND sg13g2_buf_1
Xinput48 input48/X imem_data[23] VPWR VGND sg13g2_buf_1
XFILLER_6_342 VPWR VGND sg13g2_fill_1
XFILLER_42_6 VPWR VGND sg13g2_fill_1
XFILLER_69_338 VPWR VGND sg13g2_decap_8
X_4010_ _4010_/Y _2685_/B _4479_/C _4009_/Y VPWR VGND sg13g2_o21ai_1
XFILLER_37_224 VPWR VGND sg13g2_fill_2
XFILLER_65_522 VPWR VGND sg13g2_decap_8
XFILLER_25_419 VPWR VGND sg13g2_decap_4
XFILLER_52_216 VPWR VGND sg13g2_decap_8
XFILLER_33_430 VPWR VGND sg13g2_decap_8
X_4912_ _4915_/A _4904_/Y _4907_/Y _4903_/X VPWR VGND sg13g2_o21ai_1
XFILLER_21_647 VPWR VGND sg13g2_fill_1
X_4843_ _5216_/D _4839_/A _4842_/Y _4839_/Y VPWR VGND sg13g2_a21oi_1
X_4774_ _4808_/A _4831_/A _4774_/B VPWR VGND sg13g2_xnor2_1
X_3725_ _3725_/Y _4201_/A _3405_/Y _3404_/Y VPWR VGND sg13g2_o21ai_1
Xclkbuf_leaf_9_clk _5435_/CLK clkbuf_leaf_9_clk/A VPWR VGND sg13g2_buf_8
X_3656_ _3893_/B _3896_/B _3656_/B VPWR VGND sg13g2_nand2_1
X_3587_ _3587_/Y _3587_/A _3588_/B VPWR VGND sg13g2_nor2b_1
X_2607_ _2607_/Y _2607_/A VPWR VGND sg13g2_inv_1
XFILLER_0_507 VPWR VGND sg13g2_decap_8
X_5326_ _5326_/Q clkload2/A _5326_/D _5066_/Y VPWR VGND sg13g2_dfrbpq_1
X_5257_ _5257_/Q clkload5/A _5257_/D _4997_/Y VPWR VGND sg13g2_dfrbpq_1
X_4208_ _4213_/B _4208_/A _4208_/B VPWR VGND sg13g2_nor2_1
X_5188_ _5188_/Q clkload1/A _5188_/D _4928_/Y VPWR VGND sg13g2_dfrbpq_1
X_4139_ _4139_/Y _4139_/A1 _4110_/B _4188_/B2 VPWR VGND sg13g2_a21oi_1
XFILLER_56_544 VPWR VGND sg13g2_decap_8
XFILLER_56_533 VPWR VGND sg13g2_fill_1
XFILLER_24_430 VPWR VGND sg13g2_fill_1
XFILLER_12_647 VPWR VGND sg13g2_decap_4
XFILLER_8_629 VPWR VGND sg13g2_fill_1
XFILLER_3_378 VPWR VGND sg13g2_decap_8
XFILLER_59_371 VPWR VGND sg13g2_decap_8
XFILLER_74_352 VPWR VGND sg13g2_decap_8
XFILLER_34_227 VPWR VGND sg13g2_decap_4
XFILLER_15_496 VPWR VGND sg13g2_decap_8
XFILLER_70_591 VPWR VGND sg13g2_decap_8
XFILLER_63_71 VPWR VGND sg13g2_decap_8
X_3510_ _3512_/C _5181_/Q _3456_/B _3683_/A2 _5313_/Q VPWR VGND sg13g2_a22oi_1
Xhold618 _4341_/A _5307_/Q VPWR VGND sg13g2_dlygate4sd3_1
X_4490_ _4490_/Y _4490_/A _4490_/B VPWR VGND sg13g2_xnor2_1
Xhold629 hold629/X _5414_/Q VPWR VGND sg13g2_dlygate4sd3_1
X_3441_ _3771_/A _3442_/A _3442_/B VPWR VGND sg13g2_nor2_1
X_3372_ _3372_/Y _5245_/Q _2714_/A _3372_/B1 VPWR VGND sg13g2_a21oi_1
X_5111_ _5111_/Y _5168_/A VPWR VGND sg13g2_inv_1
XFILLER_69_102 VPWR VGND sg13g2_fill_1
XFILLER_57_308 VPWR VGND sg13g2_decap_8
X_5042_ _5042_/Y _5145_/A VPWR VGND sg13g2_inv_1
XFILLER_19_0 VPWR VGND sg13g2_fill_2
XFILLER_38_555 VPWR VGND sg13g2_decap_8
XFILLER_65_330 VPWR VGND sg13g2_decap_8
XFILLER_53_514 VPWR VGND sg13g2_decap_8
XFILLER_40_208 VPWR VGND sg13g2_decap_8
XFILLER_80_355 VPWR VGND sg13g2_fill_1
XFILLER_21_400 VPWR VGND sg13g2_decap_8
XFILLER_21_455 VPWR VGND sg13g2_fill_2
X_4826_ _5214_/D _4839_/A hold852/X _4825_/Y VPWR VGND sg13g2_o21ai_1
XFILLER_61_591 VPWR VGND sg13g2_decap_8
XFILLER_21_499 VPWR VGND sg13g2_fill_1
X_4757_ _4758_/C _4756_/A _4756_/B _4756_/C VPWR VGND sg13g2_a21o_1
XFILLER_4_109 VPWR VGND sg13g2_decap_8
X_4688_ _4690_/A _4688_/A _4688_/B VPWR VGND sg13g2_xnor2_1
X_3708_ _3708_/Y _4029_/A _3708_/B VPWR VGND sg13g2_nor2_1
X_3639_ _3639_/Y _5321_/Q _3666_/B _3668_/B1 _5289_/Q _3637_/X VPWR VGND sg13g2_a221oi_1
X_5309_ _5309_/Q _5430_/CLK _5309_/D _5049_/Y VPWR VGND sg13g2_dfrbpq_1
XFILLER_56_374 VPWR VGND sg13g2_fill_1
XFILLER_44_547 VPWR VGND sg13g2_decap_8
XFILLER_71_355 VPWR VGND sg13g2_decap_8
XFILLER_12_444 VPWR VGND sg13g2_decap_8
XFILLER_33_30 VPWR VGND sg13g2_fill_1
XFILLER_4_610 VPWR VGND sg13g2_decap_8
XFILLER_3_120 VPWR VGND sg13g2_fill_1
XFILLER_79_499 VPWR VGND sg13g2_decap_8
XFILLER_12_7 VPWR VGND sg13g2_decap_4
XFILLER_47_341 VPWR VGND sg13g2_decap_8
XFILLER_81_108 VPWR VGND sg13g2_decap_8
XFILLER_74_171 VPWR VGND sg13g2_decap_8
X_3990_ _5414_/D hold629/X _3989_/Y _4013_/S VPWR VGND sg13g2_mux2_1
XFILLER_43_580 VPWR VGND sg13g2_decap_8
X_2941_ _2941_/Y _2941_/A _2941_/B VPWR VGND sg13g2_nor2_1
XFILLER_15_293 VPWR VGND sg13g2_decap_4
X_4611_ _4611_/Y _2716_/C _4638_/A _5458_/A _4618_/B2 VPWR VGND sg13g2_a22oi_1
X_2872_ _2872_/Y _2556_/Y _2819_/B _2690_/X VPWR VGND sg13g2_o21ai_1
X_4542_ _4548_/A _4543_/B _4542_/B VPWR VGND sg13g2_nand2_1
X_4473_ _4474_/D _3109_/Y _4473_/B _4473_/C VPWR VGND sg13g2_nand3b_1
X_3424_ _3426_/C _5185_/Q _3637_/B _3682_/B1 _5413_/Q VPWR VGND sg13g2_a22oi_1
X_3355_ _5466_/A _4629_/B _3355_/B VPWR VGND sg13g2_nor2_1
X_3286_ _3286_/Y _4644_/A _4195_/A2 _3222_/B VPWR VGND sg13g2_a21oi_1
XFILLER_57_105 VPWR VGND sg13g2_fill_1
X_5025_ _5025_/Y _5153_/A VPWR VGND sg13g2_inv_1
XFILLER_57_149 VPWR VGND sg13g2_decap_8
XFILLER_26_514 VPWR VGND sg13g2_decap_8
XFILLER_38_374 VPWR VGND sg13g2_decap_8
XFILLER_38_385 VPWR VGND sg13g2_fill_2
XFILLER_65_182 VPWR VGND sg13g2_decap_4
XFILLER_53_366 VPWR VGND sg13g2_decap_8
XFILLER_13_219 VPWR VGND sg13g2_decap_8
XFILLER_80_174 VPWR VGND sg13g2_decap_8
XFILLER_53_399 VPWR VGND sg13g2_decap_8
X_4809_ _4809_/Y _4809_/A _4809_/B VPWR VGND sg13g2_nand2_1
XFILLER_79_59 VPWR VGND sg13g2_decap_4
XFILLER_0_112 VPWR VGND sg13g2_decap_8
XFILLER_29_330 VPWR VGND sg13g2_decap_4
XFILLER_48_138 VPWR VGND sg13g2_decap_8
XFILLER_72_642 VPWR VGND sg13g2_decap_8
XFILLER_44_399 VPWR VGND sg13g2_decap_4
XFILLER_44_51 VPWR VGND sg13g2_decap_8
XFILLER_71_163 VPWR VGND sg13g2_decap_8
XFILLER_12_285 VPWR VGND sg13g2_decap_8
XFILLER_8_256 VPWR VGND sg13g2_fill_2
X_3140_ _3142_/B _3144_/A _3140_/B VPWR VGND sg13g2_xor2_1
XFILLER_67_447 VPWR VGND sg13g2_decap_8
XFILLER_10_4 VPWR VGND sg13g2_fill_1
X_3071_ _3096_/B _3102_/B _3095_/B VPWR VGND sg13g2_or2_1
XFILLER_23_517 VPWR VGND sg13g2_decap_8
XFILLER_50_314 VPWR VGND sg13g2_decap_8
XFILLER_16_591 VPWR VGND sg13g2_decap_8
X_3973_ _4092_/B _3973_/A _4114_/A _3973_/C _4143_/B VPWR VGND sg13g2_nor4_1
X_2924_ _3022_/A _2925_/A _2925_/B _2925_/C VPWR VGND sg13g2_and3_1
X_2855_ _2855_/Y _5232_/Q _3365_/A2 _3365_/B1 VPWR VGND sg13g2_a21oi_1
X_4525_ _4525_/Y _4543_/A _2884_/A _4524_/Y VPWR VGND sg13g2_a21oi_1
X_2786_ _2786_/Y _5238_/Q _3365_/A2 _3365_/B1 VPWR VGND sg13g2_a21oi_1
X_4456_ _5230_/D hold628/X _4483_/B _4455_/Y VPWR VGND sg13g2_a21o_1
X_4387_ _5269_/D _3198_/Y hold726/X _4387_/S VPWR VGND sg13g2_mux2_1
X_3407_ _3407_/X _3721_/A _4208_/B VPWR VGND sg13g2_and2_1
X_3338_ _3338_/Y _3765_/A _3341_/B VPWR VGND sg13g2_nand2_1
XFILLER_58_414 VPWR VGND sg13g2_decap_8
XFILLER_46_609 VPWR VGND sg13g2_decap_8
X_3269_ _3269_/Y _3269_/A _3269_/B VPWR VGND sg13g2_nand2_1
XFILLER_26_300 VPWR VGND sg13g2_decap_8
XFILLER_26_311 VPWR VGND sg13g2_fill_1
XFILLER_38_171 VPWR VGND sg13g2_decap_8
X_5008_ _5008_/Y _5168_/A VPWR VGND sg13g2_inv_1
XFILLER_38_193 VPWR VGND sg13g2_decap_8
XFILLER_26_399 VPWR VGND sg13g2_fill_1
XFILLER_41_325 VPWR VGND sg13g2_decap_4
XFILLER_81_38 VPWR VGND sg13g2_decap_8
XFILLER_41_369 VPWR VGND sg13g2_decap_4
XFILLER_22_583 VPWR VGND sg13g2_decap_8
XFILLER_30_20 VPWR VGND sg13g2_fill_1
XFILLER_30_64 VPWR VGND sg13g2_decap_8
Xhold790 hold790/X _5324_/Q VPWR VGND sg13g2_dlygate4sd3_1
XFILLER_39_84 VPWR VGND sg13g2_fill_1
XFILLER_49_447 VPWR VGND sg13g2_decap_8
XFILLER_64_406 VPWR VGND sg13g2_fill_2
XFILLER_57_480 VPWR VGND sg13g2_decap_8
XFILLER_17_355 VPWR VGND sg13g2_decap_8
XFILLER_72_450 VPWR VGND sg13g2_decap_8
XFILLER_32_314 VPWR VGND sg13g2_fill_2
XFILLER_44_163 VPWR VGND sg13g2_fill_2
XFILLER_17_399 VPWR VGND sg13g2_fill_2
XFILLER_60_634 VPWR VGND sg13g2_decap_8
XFILLER_13_550 VPWR VGND sg13g2_fill_2
XFILLER_71_60 VPWR VGND sg13g2_decap_8
X_2640_ _2666_/A _2678_/B _2640_/B VPWR VGND sg13g2_nor2_1
XFILLER_9_565 VPWR VGND sg13g2_decap_8
X_2571_ _4360_/B _4394_/B VPWR VGND sg13g2_inv_1
XFILLER_58_4 VPWR VGND sg13g2_fill_2
X_5290_ _5290_/Q clkload2/A _5290_/D _5030_/Y VPWR VGND sg13g2_dfrbpq_1
X_4310_ _5334_/D _4348_/A hold690/X _4312_/S VPWR VGND sg13g2_mux2_1
XFILLER_4_281 VPWR VGND sg13g2_decap_4
X_4241_ _5388_/D hold762/X _3840_/Y _4249_/B VPWR VGND sg13g2_mux2_1
X_4172_ _4172_/Y _4172_/A _4172_/B VPWR VGND sg13g2_nor2_1
X_3123_ _3126_/C _4439_/C _3187_/B _3236_/B1 _3101_/A VPWR VGND sg13g2_a22oi_1
X_3054_ _3055_/B _3411_/A _3051_/B _3053_/Y VPWR VGND sg13g2_o21ai_1
XFILLER_67_277 VPWR VGND sg13g2_decap_8
XFILLER_55_428 VPWR VGND sg13g2_decap_4
XFILLER_48_491 VPWR VGND sg13g2_fill_2
XFILLER_23_314 VPWR VGND sg13g2_fill_1
XFILLER_63_461 VPWR VGND sg13g2_decap_4
XFILLER_23_325 VPWR VGND sg13g2_fill_1
XFILLER_50_122 VPWR VGND sg13g2_fill_1
XFILLER_23_358 VPWR VGND sg13g2_decap_8
XFILLER_50_166 VPWR VGND sg13g2_decap_8
X_3956_ _4113_/C _4130_/A _4130_/B _3714_/C _3715_/A _4132_/A VPWR VGND sg13g2_a221oi_1
X_2907_ _3025_/B _2576_/A _5440_/A _3403_/S VPWR VGND sg13g2_mux2_1
X_3887_ _3887_/Y _3887_/A _3887_/B VPWR VGND sg13g2_nor2_1
X_2838_ _2840_/D _5425_/Q _2800_/B _3361_/B _5393_/Q VPWR VGND sg13g2_a22oi_1
X_2769_ _2769_/Y _3365_/A2 _2817_/C VPWR VGND sg13g2_nand2b_1
X_4508_ _5186_/D hold660/X _3989_/Y _4509_/S VPWR VGND sg13g2_mux2_1
X_4439_ _4442_/B _4439_/A _4439_/B _4439_/C _4439_/D VPWR VGND sg13g2_nand4_1
Xfanout500 _3627_/B _3553_/B VPWR VGND sg13g2_buf_1
Xfanout511 _3386_/B _2711_/Y VPWR VGND sg13g2_buf_1
Xfanout522 _4904_/A _2572_/Y VPWR VGND sg13g2_buf_1
Xfanout533 fanout533/X fanout545/X VPWR VGND sg13g2_buf_1
Xfanout544 _4964_/A fanout545/X VPWR VGND sg13g2_buf_1
Xfanout555 _5145_/A _5138_/A VPWR VGND sg13g2_buf_1
Xfanout566 _4951_/A _4954_/A VPWR VGND sg13g2_buf_1
Xfanout577 _3589_/A input50/X VPWR VGND sg13g2_buf_1
Xfanout588 _2724_/A _2754_/A VPWR VGND sg13g2_buf_2
XFILLER_58_244 VPWR VGND sg13g2_fill_1
XFILLER_46_428 VPWR VGND sg13g2_decap_8
XFILLER_73_214 VPWR VGND sg13g2_fill_2
XFILLER_39_491 VPWR VGND sg13g2_decap_8
XFILLER_73_258 VPWR VGND sg13g2_decap_4
XFILLER_41_100 VPWR VGND sg13g2_fill_2
XFILLER_41_122 VPWR VGND sg13g2_decap_8
XFILLER_22_391 VPWR VGND sg13g2_decap_8
XFILLER_41_96 VPWR VGND sg13g2_decap_4
XFILLER_2_24 VPWR VGND sg13g2_decap_4
XFILLER_77_586 VPWR VGND sg13g2_decap_8
XFILLER_64_236 VPWR VGND sg13g2_decap_4
XFILLER_33_601 VPWR VGND sg13g2_decap_8
XFILLER_60_431 VPWR VGND sg13g2_decap_8
X_4790_ _4809_/A _4840_/A _4791_/B VPWR VGND sg13g2_nand2_1
X_3810_ _3812_/C _3810_/A _3810_/B _3810_/C _3810_/D VPWR VGND sg13g2_nor4_1
XFILLER_20_328 VPWR VGND sg13g2_fill_2
XFILLER_32_188 VPWR VGND sg13g2_decap_8
X_3741_ _3853_/B _3945_/B _3737_/X _3740_/Y _3635_/Y _3739_/X VPWR VGND sg13g2_a221oi_1
XFILLER_60_497 VPWR VGND sg13g2_decap_8
X_3672_ _3672_/Y _3672_/A _3670_/Y VPWR VGND sg13g2_nor2b_1
XFILLER_9_362 VPWR VGND sg13g2_decap_8
X_5411_ _5411_/Q _5414_/CLK _5411_/D _5151_/Y VPWR VGND sg13g2_dfrbpq_1
X_2623_ _4719_/A _5202_/Q VPWR VGND sg13g2_inv_1
X_5342_ _5342_/Q _5424_/CLK _5342_/D _5082_/Y VPWR VGND sg13g2_dfrbpq_1
Xoutput125 dmem_addr[5] _4541_/X VPWR VGND sg13g2_buf_1
Xoutput114 dmem_addr[24] _4620_/Y VPWR VGND sg13g2_buf_1
Xoutput103 dmem_addr[14] _4579_/Y VPWR VGND sg13g2_buf_1
X_2554_ _2554_/Y _2554_/A VPWR VGND sg13g2_inv_1
XFILLER_49_0 VPWR VGND sg13g2_decap_8
Xoutput158 dmem_wdata[5] _5441_/A VPWR VGND sg13g2_buf_1
Xoutput147 dmem_wdata[24] _5460_/A VPWR VGND sg13g2_buf_1
Xoutput136 dmem_wdata[14] _5450_/A VPWR VGND sg13g2_buf_1
X_5273_ _5273_/Q clkload9/A _5273_/D _5013_/Y VPWR VGND sg13g2_dfrbpq_1
Xoutput169 imem_addr[14] _5207_/Q VPWR VGND sg13g2_buf_1
X_4224_ _4224_/Y _4224_/A _4224_/B VPWR VGND sg13g2_nand2_1
XFILLER_68_520 VPWR VGND sg13g2_decap_8
X_4155_ _4155_/Y _3721_/B _4154_/Y _4203_/A VPWR VGND sg13g2_o21ai_1
X_3106_ _3106_/Y _3106_/A _3106_/B _3106_/C _3106_/D VPWR VGND sg13g2_nand4_1
X_4086_ _5410_/D hold667/X _4085_/Y _4224_/B VPWR VGND sg13g2_mux2_1
XFILLER_55_258 VPWR VGND sg13g2_fill_1
XFILLER_43_409 VPWR VGND sg13g2_decap_8
X_3037_ _3037_/X _3201_/A _3201_/B _2813_/Y VPWR VGND sg13g2_a21o_1
XFILLER_70_228 VPWR VGND sg13g2_decap_8
XFILLER_23_144 VPWR VGND sg13g2_decap_8
XFILLER_11_317 VPWR VGND sg13g2_decap_8
XFILLER_23_166 VPWR VGND sg13g2_fill_2
XFILLER_23_177 VPWR VGND sg13g2_decap_8
XFILLER_23_188 VPWR VGND sg13g2_fill_2
X_4988_ _4988_/Y _5148_/A VPWR VGND sg13g2_inv_1
X_3939_ _3941_/C _4001_/B2 _3587_/Y _4446_/B _4069_/B2 VPWR VGND sg13g2_a22oi_1
XFILLER_3_505 VPWR VGND sg13g2_fill_1
Xfanout330 _3236_/B1 _4209_/B1 VPWR VGND sg13g2_buf_1
Xfanout341 _3253_/A _2824_/X VPWR VGND sg13g2_buf_1
Xfanout352 _4116_/B _3531_/Y VPWR VGND sg13g2_buf_1
Xfanout363 _4441_/D _3007_/Y VPWR VGND sg13g2_buf_1
Xfanout374 _3187_/A _4435_/A VPWR VGND sg13g2_buf_1
XFILLER_59_542 VPWR VGND sg13g2_fill_2
Xfanout385 _4105_/A1 _2680_/Y VPWR VGND sg13g2_buf_1
Xfanout396 _4177_/A2 _4009_/B1 VPWR VGND sg13g2_buf_1
XFILLER_74_501 VPWR VGND sg13g2_fill_1
XFILLER_36_52 VPWR VGND sg13g2_decap_4
XFILLER_46_269 VPWR VGND sg13g2_decap_8
XFILLER_14_100 VPWR VGND sg13g2_decap_4
XFILLER_15_623 VPWR VGND sg13g2_decap_4
XFILLER_42_431 VPWR VGND sg13g2_fill_1
XFILLER_14_133 VPWR VGND sg13g2_decap_8
XFILLER_14_177 VPWR VGND sg13g2_fill_1
Xinput27 _2585_/A dmem_rdata[4] VPWR VGND sg13g2_buf_1
Xinput16 _2614_/A dmem_rdata[23] VPWR VGND sg13g2_buf_1
Xinput49 input49/X imem_data[24] VPWR VGND sg13g2_buf_1
Xinput38 _4749_/A imem_data[14] VPWR VGND sg13g2_buf_1
XFILLER_6_321 VPWR VGND sg13g2_decap_4
XFILLER_6_387 VPWR VGND sg13g2_fill_2
XFILLER_6_376 VPWR VGND sg13g2_decap_8
XFILLER_69_317 VPWR VGND sg13g2_decap_8
XFILLER_2_593 VPWR VGND sg13g2_fill_2
XFILLER_18_450 VPWR VGND sg13g2_decap_8
XFILLER_65_578 VPWR VGND sg13g2_decap_8
XFILLER_18_483 VPWR VGND sg13g2_decap_8
X_4911_ _4913_/B _4911_/A _4911_/B VPWR VGND sg13g2_xor2_1
XFILLER_33_453 VPWR VGND sg13g2_fill_1
XFILLER_21_615 VPWR VGND sg13g2_fill_1
XFILLER_21_626 VPWR VGND sg13g2_decap_4
XFILLER_33_475 VPWR VGND sg13g2_fill_2
X_4842_ _4842_/Y _4845_/D _4842_/B VPWR VGND sg13g2_xnor2_1
X_4773_ _4783_/A _4831_/A _4774_/B VPWR VGND sg13g2_nor2_1
XFILLER_60_294 VPWR VGND sg13g2_decap_8
X_3724_ _3729_/A _3724_/A _3724_/B _3724_/C _3728_/B VPWR VGND sg13g2_nand4_1
X_3655_ _3739_/C _3896_/B _3656_/B VPWR VGND sg13g2_and2_1
X_2606_ _2606_/Y _2606_/A VPWR VGND sg13g2_inv_1
X_3586_ _3587_/A _5256_/Q _4615_/A1 _3671_/B1 VPWR VGND sg13g2_a21oi_1
X_5325_ _5325_/Q clkload3/A _5325_/D _5065_/Y VPWR VGND sg13g2_dfrbpq_1
X_5256_ _5256_/Q clkload8/A _5256_/D _4996_/Y VPWR VGND sg13g2_dfrbpq_1
X_4207_ _4213_/A _4207_/A _4207_/B VPWR VGND sg13g2_nor2_1
XFILLER_28_203 VPWR VGND sg13g2_decap_8
X_5187_ _5187_/Q clkload1/A _5187_/D _4927_/Y VPWR VGND sg13g2_dfrbpq_1
XFILLER_68_383 VPWR VGND sg13g2_decap_8
XFILLER_68_350 VPWR VGND sg13g2_decap_8
XFILLER_56_512 VPWR VGND sg13g2_fill_2
X_4138_ _4138_/Y _4188_/A1 _3567_/B _4209_/A1 VPWR VGND sg13g2_a21oi_1
XFILLER_16_409 VPWR VGND sg13g2_decap_8
X_4069_ _4071_/B _3847_/A _4450_/B _4065_/A _4069_/B2 VPWR VGND sg13g2_a22oi_1
XFILLER_43_217 VPWR VGND sg13g2_fill_2
XFILLER_12_626 VPWR VGND sg13g2_decap_4
XFILLER_24_497 VPWR VGND sg13g2_fill_2
XFILLER_11_125 VPWR VGND sg13g2_fill_1
XFILLER_19_225 VPWR VGND sg13g2_fill_1
XFILLER_74_331 VPWR VGND sg13g2_decap_8
XFILLER_47_95 VPWR VGND sg13g2_decap_4
XFILLER_74_386 VPWR VGND sg13g2_decap_8
XFILLER_15_464 VPWR VGND sg13g2_decap_4
XFILLER_30_412 VPWR VGND sg13g2_decap_8
XFILLER_70_570 VPWR VGND sg13g2_fill_1
XFILLER_30_478 VPWR VGND sg13g2_decap_4
XFILLER_30_489 VPWR VGND sg13g2_fill_2
Xhold619 _4380_/A _5275_/Q VPWR VGND sg13g2_dlygate4sd3_1
X_3440_ _3442_/B _3440_/A _3440_/B VPWR VGND sg13g2_nand2_1
XFILLER_40_4 VPWR VGND sg13g2_fill_1
X_3371_ _3371_/Y _5277_/Q _3371_/A2 _3371_/B1 _5341_/Q _3370_/Y VPWR VGND sg13g2_a221oi_1
X_5110_ _5110_/Y _5174_/A VPWR VGND sg13g2_inv_1
X_5041_ _5041_/Y _5175_/A VPWR VGND sg13g2_inv_1
XFILLER_77_180 VPWR VGND sg13g2_fill_1
XFILLER_65_342 VPWR VGND sg13g2_fill_1
XFILLER_65_386 VPWR VGND sg13g2_decap_8
XFILLER_53_537 VPWR VGND sg13g2_fill_1
XFILLER_21_434 VPWR VGND sg13g2_decap_8
X_4825_ _4825_/Y _4839_/A _4825_/B VPWR VGND sg13g2_nand2_1
X_4756_ _4758_/B _4756_/A _4756_/B _4756_/C VPWR VGND sg13g2_nand3_1
X_4687_ _4687_/Y _4688_/A _4688_/B VPWR VGND sg13g2_nand2_1
X_3707_ _3713_/C _3999_/B _3983_/B VPWR VGND sg13g2_or2_1
X_3638_ _3638_/X _5417_/Q _3682_/B1 _2817_/C VPWR VGND sg13g2_a21o_1
X_3569_ _3570_/B _4114_/A _3569_/B VPWR VGND sg13g2_nor2_1
X_5308_ _5308_/Q _5392_/CLK _5308_/D _5048_/Y VPWR VGND sg13g2_dfrbpq_1
XFILLER_68_39 VPWR VGND sg13g2_fill_1
XFILLER_76_607 VPWR VGND sg13g2_decap_4
XFILLER_29_512 VPWR VGND sg13g2_fill_1
X_5239_ _5239_/Q _5425_/CLK _5239_/D _4979_/Y VPWR VGND sg13g2_dfrbpq_1
XFILLER_29_556 VPWR VGND sg13g2_decap_8
XFILLER_29_578 VPWR VGND sg13g2_decap_4
XFILLER_44_526 VPWR VGND sg13g2_decap_8
XFILLER_71_345 VPWR VGND sg13g2_decap_4
XFILLER_12_434 VPWR VGND sg13g2_decap_4
XFILLER_24_283 VPWR VGND sg13g2_decap_8
XFILLER_79_423 VPWR VGND sg13g2_fill_1
XFILLER_79_412 VPWR VGND sg13g2_fill_1
XFILLER_79_456 VPWR VGND sg13g2_decap_8
XFILLER_47_386 VPWR VGND sg13g2_decap_8
XFILLER_62_312 VPWR VGND sg13g2_decap_8
XFILLER_35_559 VPWR VGND sg13g2_decap_8
XFILLER_74_93 VPWR VGND sg13g2_fill_2
X_2940_ _2940_/Y _2550_/Y _3368_/B _3372_/B1 VPWR VGND sg13g2_o21ai_1
X_2871_ _2871_/Y _5295_/Q _2920_/A2 _3004_/B1 _5391_/Q _2870_/X VPWR VGND sg13g2_a221oi_1
X_4610_ _4610_/Y _4614_/B _4609_/Y VPWR VGND sg13g2_nor2b_1
X_4541_ _4541_/X _4539_/B _4540_/X _4542_/B VPWR VGND sg13g2_a21o_1
X_4472_ _4473_/C _4472_/A _4472_/B _4472_/C _4472_/D VPWR VGND sg13g2_and4_1
X_3423_ _3426_/B _5317_/Q _3666_/B _3668_/B1 _5285_/Q VPWR VGND sg13g2_a22oi_1
X_3354_ _3355_/B _5261_/Q _2754_/B _3353_/Y VPWR VGND sg13g2_o21ai_1
X_3285_ _3285_/Y _4217_/A1 _4470_/B _3284_/Y VPWR VGND sg13g2_o21ai_1
X_5024_ _5024_/Y _5153_/A VPWR VGND sg13g2_inv_1
XFILLER_66_651 VPWR VGND sg13g2_fill_1
XFILLER_81_632 VPWR VGND sg13g2_decap_4
XFILLER_26_559 VPWR VGND sg13g2_decap_8
XFILLER_53_334 VPWR VGND sg13g2_decap_8
XFILLER_41_518 VPWR VGND sg13g2_decap_8
XFILLER_41_529 VPWR VGND sg13g2_decap_8
XFILLER_21_231 VPWR VGND sg13g2_fill_2
X_4808_ _4846_/B _4808_/A _4808_/B _4808_/C _4808_/D VPWR VGND sg13g2_or4_1
X_4739_ _5205_/D _4739_/A1 _4737_/Y _4738_/Y VPWR VGND sg13g2_a21oi_1
XFILLER_0_157 VPWR VGND sg13g2_decap_8
XFILLER_76_404 VPWR VGND sg13g2_fill_1
XFILLER_28_53 VPWR VGND sg13g2_decap_8
XFILLER_29_386 VPWR VGND sg13g2_decap_8
XFILLER_44_345 VPWR VGND sg13g2_decap_8
XFILLER_44_378 VPWR VGND sg13g2_decap_8
XFILLER_4_463 VPWR VGND sg13g2_decap_4
XFILLER_4_496 VPWR VGND sg13g2_decap_4
XFILLER_69_71 VPWR VGND sg13g2_decap_8
X_3070_ _5435_/D _4517_/S _3068_/Y _3069_/Y VPWR VGND sg13g2_a21oi_1
XFILLER_67_426 VPWR VGND sg13g2_decap_8
XFILLER_35_312 VPWR VGND sg13g2_fill_1
XFILLER_47_172 VPWR VGND sg13g2_decap_8
XFILLER_35_334 VPWR VGND sg13g2_fill_2
XFILLER_75_492 VPWR VGND sg13g2_decap_8
XFILLER_35_378 VPWR VGND sg13g2_decap_4
XFILLER_35_389 VPWR VGND sg13g2_decap_4
X_3972_ _4114_/B _3973_/C _4143_/B VPWR VGND sg13g2_nor2_1
XFILLER_31_551 VPWR VGND sg13g2_decap_4
XFILLER_50_359 VPWR VGND sg13g2_decap_8
X_2923_ _2925_/C _2923_/A _2923_/B VPWR VGND sg13g2_and2_1
X_2854_ _2854_/Y _5328_/Q _3004_/A2 _3003_/B1 _5264_/Q _2853_/Y VPWR VGND sg13g2_a221oi_1
X_2785_ _2785_/Y _5334_/Q _3363_/A2 _3363_/B1 _5270_/Q _2784_/Y VPWR VGND sg13g2_a221oi_1
XFILLER_79_0 VPWR VGND sg13g2_decap_8
X_4524_ _4524_/Y _4524_/A _4543_/A VPWR VGND sg13g2_nor2_1
X_4455_ _4455_/Y _2684_/A _3823_/A _4430_/Y _4454_/Y _4483_/B VPWR VGND sg13g2_a221oi_1
X_4386_ _5270_/D _4348_/A hold722/X _4388_/S VPWR VGND sg13g2_mux2_1
X_3406_ _4201_/C _4206_/B _3406_/B VPWR VGND sg13g2_xnor2_1
X_3337_ _3337_/Y _3765_/A _3341_/B VPWR VGND sg13g2_nor2_1
X_3268_ _3268_/Y _3270_/A _3268_/B _3268_/C VPWR VGND sg13g2_nor3_1
XFILLER_58_459 VPWR VGND sg13g2_decap_8
X_5007_ _5007_/Y _5167_/A VPWR VGND sg13g2_inv_1
X_3199_ _5429_/D hold829/X _3198_/Y _4517_/S VPWR VGND sg13g2_mux2_1
XFILLER_26_323 VPWR VGND sg13g2_fill_2
XFILLER_26_367 VPWR VGND sg13g2_decap_4
XFILLER_41_304 VPWR VGND sg13g2_decap_8
XFILLER_53_153 VPWR VGND sg13g2_fill_1
XFILLER_53_142 VPWR VGND sg13g2_decap_8
XFILLER_22_562 VPWR VGND sg13g2_decap_8
XFILLER_14_66 VPWR VGND sg13g2_decap_8
XFILLER_5_227 VPWR VGND sg13g2_fill_2
Xhold791 hold791/X _5350_/Q VPWR VGND sg13g2_dlygate4sd3_1
Xhold780 hold780/X _5330_/Q VPWR VGND sg13g2_dlygate4sd3_1
XFILLER_76_223 VPWR VGND sg13g2_decap_8
XFILLER_76_245 VPWR VGND sg13g2_fill_1
XFILLER_17_312 VPWR VGND sg13g2_decap_8
XFILLER_76_289 VPWR VGND sg13g2_decap_8
XFILLER_64_429 VPWR VGND sg13g2_decap_4
XFILLER_44_131 VPWR VGND sg13g2_fill_1
XFILLER_72_462 VPWR VGND sg13g2_fill_1
XFILLER_72_484 VPWR VGND sg13g2_decap_8
XFILLER_13_595 VPWR VGND sg13g2_decap_8
XFILLER_40_381 VPWR VGND sg13g2_decap_8
XFILLER_9_544 VPWR VGND sg13g2_decap_8
XFILLER_40_392 VPWR VGND sg13g2_fill_1
XFILLER_9_588 VPWR VGND sg13g2_fill_1
XFILLER_65_6 VPWR VGND sg13g2_fill_1
X_2570_ _4394_/A _4360_/A VPWR VGND sg13g2_inv_1
X_4240_ _5389_/D hold760/X _3815_/Y _4249_/B VPWR VGND sg13g2_mux2_1
X_4171_ _4172_/B _4152_/A _4152_/B _4171_/B1 VPWR VGND sg13g2_o21ai_1
X_3122_ _3126_/B _4188_/A1 _2951_/A _3724_/B _4188_/B2 VPWR VGND sg13g2_a22oi_1
X_3053_ _3053_/Y _3053_/A _3020_/Y VPWR VGND sg13g2_nor2b_1
XFILLER_35_131 VPWR VGND sg13g2_decap_4
XFILLER_23_337 VPWR VGND sg13g2_decap_8
XFILLER_51_635 VPWR VGND sg13g2_decap_8
X_3955_ _4131_/B _4130_/A _4130_/B _4132_/A VPWR VGND sg13g2_a21oi_1
XFILLER_31_370 VPWR VGND sg13g2_decap_8
X_2906_ _4568_/C _2904_/Y _2902_/Y _2905_/Y VPWR VGND sg13g2_a21oi_2
X_3886_ _4481_/B _3886_/A _3886_/B _3886_/C _3886_/D VPWR VGND sg13g2_nand4_1
X_2837_ _2840_/C _5361_/Q _3003_/A2 _2920_/A2 _5297_/Q VPWR VGND sg13g2_a22oi_1
X_2768_ _2770_/D _5237_/Q _2938_/B VPWR VGND sg13g2_nand2_1
X_4507_ _5187_/D hold725/X _3953_/Y _4514_/S VPWR VGND sg13g2_mux2_1
X_2699_ _2818_/B _2704_/B _2895_/C _2704_/C VPWR VGND sg13g2_nand3b_1
X_4438_ _4438_/X _4438_/A _4438_/B _4438_/C _4438_/D VPWR VGND sg13g2_and4_1
Xfanout501 _2841_/B _3397_/B VPWR VGND sg13g2_buf_2
Xfanout512 _3368_/B _2711_/Y VPWR VGND sg13g2_buf_1
Xfanout523 _4831_/A _2572_/Y VPWR VGND sg13g2_buf_1
Xfanout534 _5152_/A _5173_/A VPWR VGND sg13g2_buf_1
Xfanout545 fanout545/X input97/X VPWR VGND sg13g2_buf_1
Xfanout556 _5138_/A _5170_/A VPWR VGND sg13g2_buf_1
X_4369_ _5286_/D _3989_/Y hold653/X _4375_/S VPWR VGND sg13g2_mux2_1
XFILLER_76_17 VPWR VGND sg13g2_fill_2
XFILLER_58_201 VPWR VGND sg13g2_fill_1
XFILLER_46_407 VPWR VGND sg13g2_decap_8
Xfanout567 _4954_/A _4942_/A VPWR VGND sg13g2_buf_1
Xfanout578 _2704_/C _2895_/B VPWR VGND sg13g2_buf_1
Xfanout589 _2754_/A input45/X VPWR VGND sg13g2_buf_8
XFILLER_18_109 VPWR VGND sg13g2_decap_8
XFILLER_42_602 VPWR VGND sg13g2_fill_2
XFILLER_26_197 VPWR VGND sg13g2_fill_2
XFILLER_14_359 VPWR VGND sg13g2_fill_1
XFILLER_41_178 VPWR VGND sg13g2_fill_2
XFILLER_41_20 VPWR VGND sg13g2_fill_1
XFILLER_41_31 VPWR VGND sg13g2_decap_4
XFILLER_10_576 VPWR VGND sg13g2_fill_2
XFILLER_41_53 VPWR VGND sg13g2_fill_1
XFILLER_41_75 VPWR VGND sg13g2_decap_8
XFILLER_10_598 VPWR VGND sg13g2_decap_4
XFILLER_6_558 VPWR VGND sg13g2_fill_2
XFILLER_9_0 VPWR VGND sg13g2_decap_4
XFILLER_2_58 VPWR VGND sg13g2_fill_1
XFILLER_66_72 VPWR VGND sg13g2_fill_2
XFILLER_17_142 VPWR VGND sg13g2_fill_2
XFILLER_45_451 VPWR VGND sg13g2_fill_2
XFILLER_17_186 VPWR VGND sg13g2_fill_2
XFILLER_45_495 VPWR VGND sg13g2_decap_8
X_3740_ _3740_/Y _3879_/B _3879_/C _3656_/B VPWR VGND sg13g2_o21ai_1
XFILLER_60_487 VPWR VGND sg13g2_fill_1
X_3671_ _3672_/A _5260_/Q _2694_/B _3671_/B1 VPWR VGND sg13g2_a21oi_1
X_5410_ _5410_/Q clkload7/A _5410_/D _5150_/Y VPWR VGND sg13g2_dfrbpq_1
X_2622_ _2622_/Y _2622_/A VPWR VGND sg13g2_inv_1
X_5341_ _5341_/Q _5430_/CLK _5341_/D _5081_/Y VPWR VGND sg13g2_dfrbpq_1
Xoutput115 dmem_addr[25] _4624_/Y VPWR VGND sg13g2_buf_1
Xoutput104 dmem_addr[15] _4583_/Y VPWR VGND sg13g2_buf_1
X_2553_ _2819_/A _2553_/A VPWR VGND sg13g2_inv_1
Xoutput159 dmem_wdata[6] _5442_/A VPWR VGND sg13g2_buf_1
Xoutput148 dmem_wdata[25] _5461_/A VPWR VGND sg13g2_buf_1
Xoutput137 dmem_wdata[15] _5451_/A VPWR VGND sg13g2_buf_1
Xoutput126 dmem_addr[6] _4545_/Y VPWR VGND sg13g2_buf_1
X_5272_ _5272_/Q _5432_/CLK _5272_/D _5012_/Y VPWR VGND sg13g2_dfrbpq_1
X_4223_ _5402_/D hold712/X _3093_/Y _4237_/S VPWR VGND sg13g2_mux2_1
X_4154_ _4154_/Y _2970_/B _3720_/Y _3725_/Y VPWR VGND sg13g2_a21oi_1
XFILLER_28_407 VPWR VGND sg13g2_decap_8
X_4085_ _4085_/Y _2605_/Y _4128_/A2 _4083_/X _4084_/Y VPWR VGND sg13g2_a22oi_1
X_3105_ _3106_/D _4439_/A _3018_/A _4188_/B2 VPWR VGND sg13g2_o21ai_1
X_3036_ _3036_/Y _3201_/A _3201_/B _2813_/Y VPWR VGND sg13g2_a21oi_1
XFILLER_70_207 VPWR VGND sg13g2_fill_1
XFILLER_24_646 VPWR VGND sg13g2_fill_2
XFILLER_51_410 VPWR VGND sg13g2_fill_1
XFILLER_23_123 VPWR VGND sg13g2_decap_8
XFILLER_51_432 VPWR VGND sg13g2_decap_4
XFILLER_51_498 VPWR VGND sg13g2_decap_8
X_4987_ _4987_/Y _5147_/A VPWR VGND sg13g2_inv_1
X_3938_ _3941_/B _3938_/A _3938_/B VPWR VGND sg13g2_nand2_1
X_3869_ _3869_/Y _3658_/Y _3866_/B _3856_/A VPWR VGND sg13g2_a21oi_1
XFILLER_3_539 VPWR VGND sg13g2_fill_1
XFILLER_2_7 VPWR VGND sg13g2_decap_4
Xfanout320 _4059_/A2 output130/A VPWR VGND sg13g2_buf_1
Xfanout331 _4209_/B1 _4464_/A2 VPWR VGND sg13g2_buf_1
XFILLER_59_521 VPWR VGND sg13g2_decap_8
Xfanout342 _4435_/B _3210_/B VPWR VGND sg13g2_buf_1
Xfanout353 _4448_/D _3531_/Y VPWR VGND sg13g2_buf_1
Xfanout364 _3938_/A _4095_/A VPWR VGND sg13g2_buf_1
Xfanout375 _3191_/A _4435_/A VPWR VGND sg13g2_buf_1
XFILLER_19_407 VPWR VGND sg13g2_decap_8
Xfanout386 _4217_/A1 _4146_/A2 VPWR VGND sg13g2_buf_1
Xfanout397 _4009_/B1 _2657_/Y VPWR VGND sg13g2_buf_1
XFILLER_46_237 VPWR VGND sg13g2_decap_4
XFILLER_74_579 VPWR VGND sg13g2_decap_8
XFILLER_15_613 VPWR VGND sg13g2_fill_2
XFILLER_42_410 VPWR VGND sg13g2_decap_8
XFILLER_61_218 VPWR VGND sg13g2_decap_8
XFILLER_30_605 VPWR VGND sg13g2_decap_4
XFILLER_42_476 VPWR VGND sg13g2_decap_4
XFILLER_42_498 VPWR VGND sg13g2_decap_8
Xinput28 _3222_/A dmem_rdata[5] VPWR VGND sg13g2_buf_1
Xinput17 _2616_/A dmem_rdata[24] VPWR VGND sg13g2_buf_1
Xinput39 input39/X imem_data[15] VPWR VGND sg13g2_buf_1
XFILLER_6_355 VPWR VGND sg13g2_decap_8
XFILLER_6_399 VPWR VGND sg13g2_fill_2
XFILLER_2_550 VPWR VGND sg13g2_fill_1
XFILLER_35_7 VPWR VGND sg13g2_decap_8
XFILLER_77_340 VPWR VGND sg13g2_decap_8
XFILLER_37_204 VPWR VGND sg13g2_decap_8
XFILLER_77_362 VPWR VGND sg13g2_decap_4
XFILLER_37_226 VPWR VGND sg13g2_fill_1
XFILLER_37_237 VPWR VGND sg13g2_decap_4
XFILLER_65_557 VPWR VGND sg13g2_decap_8
XFILLER_18_462 VPWR VGND sg13g2_decap_8
XFILLER_37_259 VPWR VGND sg13g2_decap_8
XFILLER_33_410 VPWR VGND sg13g2_decap_8
X_4910_ _5223_/D _4914_/A hold847/X _4909_/X VPWR VGND sg13g2_o21ai_1
X_4841_ _4842_/B _4840_/A _4831_/B _4833_/X VPWR VGND sg13g2_a21oi_1
XFILLER_60_273 VPWR VGND sg13g2_decap_8
X_4772_ _4774_/B _4772_/A _4787_/D VPWR VGND sg13g2_xnor2_1
X_3723_ _4132_/B _2918_/A _2918_/B _3722_/Y VPWR VGND sg13g2_a21oi_1
X_3654_ _3656_/B _3895_/A _3654_/B VPWR VGND sg13g2_nand2_1
X_2605_ _2605_/Y _2605_/A VPWR VGND sg13g2_inv_1
X_3585_ _3588_/B _3585_/A _3585_/B _3585_/C _3585_/D VPWR VGND sg13g2_nand4_1
X_5324_ _5324_/Q clkload3/A _5324_/D _5064_/Y VPWR VGND sg13g2_dfrbpq_1
X_5255_ _5255_/Q clkload0/A _5255_/D _4995_/Y VPWR VGND sg13g2_dfrbpq_1
X_4206_ _4207_/B _4206_/A _4206_/B VPWR VGND sg13g2_xnor2_1
X_5186_ _5186_/Q _5421_/CLK _5186_/D _4926_/Y VPWR VGND sg13g2_dfrbpq_1
X_4137_ _4137_/Y _3166_/B _4143_/A _4136_/Y VPWR VGND sg13g2_o21ai_1
X_4068_ _4071_/A _4068_/A _4068_/B VPWR VGND sg13g2_nand2_1
XFILLER_73_18 VPWR VGND sg13g2_fill_2
X_3019_ _3019_/Y _3773_/A _3019_/B VPWR VGND sg13g2_nor2_1
XFILLER_71_527 VPWR VGND sg13g2_fill_2
XFILLER_51_284 VPWR VGND sg13g2_decap_8
XFILLER_0_4 VPWR VGND sg13g2_decap_8
XFILLER_79_605 VPWR VGND sg13g2_decap_8
XFILLER_78_126 VPWR VGND sg13g2_decap_8
XFILLER_59_340 VPWR VGND sg13g2_fill_1
XFILLER_47_535 VPWR VGND sg13g2_decap_8
XFILLER_47_63 VPWR VGND sg13g2_decap_8
XFILLER_47_74 VPWR VGND sg13g2_decap_4
XFILLER_15_443 VPWR VGND sg13g2_decap_8
XFILLER_15_454 VPWR VGND sg13g2_fill_2
XFILLER_63_40 VPWR VGND sg13g2_decap_8
XFILLER_42_295 VPWR VGND sg13g2_decap_8
XFILLER_30_457 VPWR VGND sg13g2_decap_8
XFILLER_8_35 VPWR VGND sg13g2_fill_2
X_3370_ _3370_/Y _2558_/Y _2941_/B _3372_/B1 VPWR VGND sg13g2_o21ai_1
XFILLER_2_380 VPWR VGND sg13g2_decap_8
XFILLER_33_4 VPWR VGND sg13g2_decap_8
X_5040_ _5040_/Y _5168_/A VPWR VGND sg13g2_inv_1
XFILLER_38_502 VPWR VGND sg13g2_fill_1
XFILLER_19_2 VPWR VGND sg13g2_fill_1
XFILLER_61_560 VPWR VGND sg13g2_fill_2
X_4824_ _4825_/B _4845_/B _4824_/B VPWR VGND sg13g2_xnor2_1
XFILLER_21_457 VPWR VGND sg13g2_fill_1
X_4755_ _4756_/C _4737_/A _4753_/X _4754_/Y VPWR VGND sg13g2_o21ai_1
X_3706_ _3706_/Y _3746_/A _3706_/B VPWR VGND sg13g2_xnor2_1
X_4686_ _4688_/B _4694_/B _4686_/B VPWR VGND sg13g2_and2_1
X_3637_ _3637_/X _5189_/Q _3637_/B VPWR VGND sg13g2_and2_1
X_3568_ _4113_/B _3714_/C _3715_/A _3552_/A _3552_/B _3567_/B VPWR VGND sg13g2_a221oi_1
X_5307_ _5307_/Q _5430_/CLK _5307_/D _5047_/Y VPWR VGND sg13g2_dfrbpq_1
XFILLER_0_339 VPWR VGND sg13g2_decap_4
X_3499_ _3502_/B _5182_/Q _3627_/B _3555_/B1 _5410_/Q VPWR VGND sg13g2_a22oi_1
X_5238_ _5238_/Q _5425_/CLK _5238_/D _4978_/Y VPWR VGND sg13g2_dfrbpq_1
XFILLER_76_619 VPWR VGND sg13g2_decap_8
X_5169_ _5169_/Y _5170_/A VPWR VGND sg13g2_inv_1
XFILLER_56_365 VPWR VGND sg13g2_fill_2
XFILLER_16_218 VPWR VGND sg13g2_decap_8
XFILLER_71_313 VPWR VGND sg13g2_decap_8
XFILLER_17_88 VPWR VGND sg13g2_decap_8
XFILLER_12_402 VPWR VGND sg13g2_fill_2
XFILLER_52_571 VPWR VGND sg13g2_decap_4
XFILLER_4_645 VPWR VGND sg13g2_decap_8
XFILLER_3_155 VPWR VGND sg13g2_fill_2
XFILLER_3_166 VPWR VGND sg13g2_decap_4
XFILLER_58_95 VPWR VGND sg13g2_decap_8
XFILLER_35_516 VPWR VGND sg13g2_decap_4
XFILLER_35_527 VPWR VGND sg13g2_decap_8
XFILLER_62_324 VPWR VGND sg13g2_fill_2
XFILLER_74_72 VPWR VGND sg13g2_decap_8
XFILLER_62_368 VPWR VGND sg13g2_decap_4
XFILLER_15_273 VPWR VGND sg13g2_fill_2
X_2870_ _2870_/X _5423_/Q _2870_/B VPWR VGND sg13g2_and2_1
XFILLER_30_298 VPWR VGND sg13g2_decap_8
Xclkbuf_leaf_10_clk _5425_/CLK clkbuf_2_3__f_clk/X VPWR VGND sg13g2_buf_8
X_4540_ _4540_/X _4670_/A _5441_/A _4543_/A VPWR VGND sg13g2_mux2_1
X_4471_ _4472_/D _4471_/A _4471_/B VPWR VGND sg13g2_and2_1
XFILLER_7_472 VPWR VGND sg13g2_decap_8
X_3422_ _3426_/A _5253_/Q _3685_/B VPWR VGND sg13g2_nand2_1
X_3353_ _3353_/Y _3353_/A _3353_/B _3353_/C _3353_/D VPWR VGND sg13g2_nand4_1
X_3284_ _3284_/Y _2581_/Y _4217_/A1 _4195_/A2 VPWR VGND sg13g2_a21oi_1
X_5023_ _5023_/Y _5154_/A VPWR VGND sg13g2_inv_1
XFILLER_81_611 VPWR VGND sg13g2_decap_8
XFILLER_53_313 VPWR VGND sg13g2_decap_8
XFILLER_53_302 VPWR VGND sg13g2_fill_2
XFILLER_21_221 VPWR VGND sg13g2_decap_4
XFILLER_34_582 VPWR VGND sg13g2_decap_8
XFILLER_21_254 VPWR VGND sg13g2_decap_4
X_4807_ _4845_/A _4807_/A _4814_/B VPWR VGND sg13g2_xnor2_1
X_2999_ _2999_/Y _2999_/A _2999_/B _2999_/C VPWR VGND sg13g2_nor3_1
X_4738_ _4738_/Y _4745_/S _4738_/B VPWR VGND sg13g2_nor2_1
X_4669_ _4669_/Y _4670_/A _4670_/B VPWR VGND sg13g2_nand2_1
XFILLER_1_604 VPWR VGND sg13g2_decap_8
XFILLER_29_321 VPWR VGND sg13g2_decap_4
XFILLER_76_427 VPWR VGND sg13g2_fill_2
XFILLER_29_354 VPWR VGND sg13g2_decap_8
XFILLER_17_527 VPWR VGND sg13g2_decap_8
XFILLER_17_538 VPWR VGND sg13g2_fill_1
XFILLER_44_324 VPWR VGND sg13g2_decap_8
XFILLER_56_184 VPWR VGND sg13g2_fill_1
XFILLER_25_582 VPWR VGND sg13g2_decap_8
XFILLER_25_593 VPWR VGND sg13g2_fill_2
XFILLER_12_254 VPWR VGND sg13g2_fill_1
XFILLER_12_265 VPWR VGND sg13g2_decap_4
XFILLER_8_225 VPWR VGND sg13g2_decap_4
XFILLER_8_269 VPWR VGND sg13g2_fill_1
XFILLER_8_258 VPWR VGND sg13g2_fill_1
XFILLER_60_63 VPWR VGND sg13g2_fill_2
XFILLER_4_442 VPWR VGND sg13g2_decap_8
XFILLER_5_58 VPWR VGND sg13g2_fill_2
XFILLER_67_405 VPWR VGND sg13g2_decap_4
XFILLER_47_151 VPWR VGND sg13g2_decap_8
XFILLER_47_195 VPWR VGND sg13g2_decap_8
XFILLER_16_560 VPWR VGND sg13g2_fill_1
X_3971_ _3977_/A _4462_/A _3971_/B VPWR VGND sg13g2_nand2_1
X_2922_ _2923_/B _5368_/Q _3547_/B1 _3361_/B _5400_/Q VPWR VGND sg13g2_a22oi_1
XFILLER_62_198 VPWR VGND sg13g2_fill_1
XFILLER_31_530 VPWR VGND sg13g2_decap_8
X_2853_ _2853_/Y _2555_/Y _2819_/B _3365_/B1 VPWR VGND sg13g2_o21ai_1
X_2784_ _2784_/Y _2789_/A _2818_/B _3365_/B1 VPWR VGND sg13g2_o21ai_1
X_4523_ _4523_/Y _4523_/A _4523_/B _4523_/C VPWR VGND sg13g2_nor3_1
X_4454_ _4454_/Y _3295_/B _4453_/Y _4432_/Y VPWR VGND sg13g2_a21oi_1
X_4385_ _5271_/D _4346_/A hold800/X _4388_/S VPWR VGND sg13g2_mux2_1
X_3405_ _3405_/Y _4206_/B _3406_/B VPWR VGND sg13g2_nor2_1
X_3336_ _3341_/B _3679_/A _5467_/A VPWR VGND sg13g2_nor2_1
X_5006_ _5006_/Y _5166_/A VPWR VGND sg13g2_inv_1
X_3267_ _5426_/D hold777/X _4355_/A _4518_/S VPWR VGND sg13g2_mux2_1
XFILLER_38_151 VPWR VGND sg13g2_decap_4
X_3198_ _3198_/Y _2586_/Y _3222_/B _3196_/X _3197_/Y VPWR VGND sg13g2_a22oi_1
XFILLER_54_622 VPWR VGND sg13g2_fill_1
XFILLER_54_611 VPWR VGND sg13g2_decap_8
XFILLER_81_441 VPWR VGND sg13g2_fill_1
XFILLER_53_121 VPWR VGND sg13g2_decap_8
XFILLER_30_11 VPWR VGND sg13g2_fill_1
XFILLER_5_206 VPWR VGND sg13g2_decap_8
XFILLER_30_44 VPWR VGND sg13g2_decap_4
Xhold781 hold781/X _5294_/Q VPWR VGND sg13g2_dlygate4sd3_1
Xhold770 hold770/X _5425_/Q VPWR VGND sg13g2_dlygate4sd3_1
XFILLER_1_445 VPWR VGND sg13g2_fill_2
Xhold792 hold792/X _5434_/Q VPWR VGND sg13g2_dlygate4sd3_1
XFILLER_1_489 VPWR VGND sg13g2_decap_8
XFILLER_39_97 VPWR VGND sg13g2_fill_2
XFILLER_76_268 VPWR VGND sg13g2_decap_8
XFILLER_32_316 VPWR VGND sg13g2_fill_1
XFILLER_32_338 VPWR VGND sg13g2_decap_8
XFILLER_13_552 VPWR VGND sg13g2_fill_1
XFILLER_32_349 VPWR VGND sg13g2_fill_1
XFILLER_40_360 VPWR VGND sg13g2_decap_8
XFILLER_9_523 VPWR VGND sg13g2_decap_8
XFILLER_4_250 VPWR VGND sg13g2_fill_1
X_4170_ _4170_/X _4203_/A _4170_/B VPWR VGND sg13g2_and2_1
X_3121_ _3121_/Y _4208_/A _3131_/A VPWR VGND sg13g2_nor2_1
X_3052_ _3053_/A _3411_/A _3411_/B VPWR VGND sg13g2_nor2_1
XFILLER_55_419 VPWR VGND sg13g2_fill_1
XFILLER_55_408 VPWR VGND sg13g2_decap_8
XFILLER_35_110 VPWR VGND sg13g2_decap_8
X_3954_ _5415_/D hold671/X _3953_/Y _4179_/S VPWR VGND sg13g2_mux2_1
X_3885_ _3886_/D _3885_/A _3885_/B _3885_/C VPWR VGND sg13g2_nor3_1
X_2905_ _2905_/Y _5235_/Q _2714_/A _3372_/B1 VPWR VGND sg13g2_a21oi_1
X_2836_ _2840_/B _5329_/Q _3363_/A2 _3363_/B1 _5265_/Q VPWR VGND sg13g2_a22oi_1
X_2767_ _2770_/C _5429_/Q _2800_/B _3003_/A2 _5365_/Q VPWR VGND sg13g2_a22oi_1
X_4506_ _5188_/D hold719/X _3932_/B _4514_/S VPWR VGND sg13g2_mux2_1
X_2698_ _2698_/Y _2704_/B _2698_/B VPWR VGND sg13g2_nor2_1
X_4437_ _4438_/D _4441_/B _4441_/C _4439_/A _4441_/D VPWR VGND sg13g2_nor4_1
Xfanout502 _3397_/B _3553_/B VPWR VGND sg13g2_buf_2
Xfanout513 _3637_/B _3456_/B VPWR VGND sg13g2_buf_1
Xfanout524 _5125_/A _5161_/A VPWR VGND sg13g2_buf_1
Xfanout535 _5154_/A _5173_/A VPWR VGND sg13g2_buf_1
Xfanout546 _5134_/A fanout550/X VPWR VGND sg13g2_buf_1
Xfanout557 _5168_/A _5175_/A VPWR VGND sg13g2_buf_1
X_4368_ _5287_/D _3953_/Y hold804/X _4375_/S VPWR VGND sg13g2_mux2_1
Xfanout568 _4942_/A _4959_/A VPWR VGND sg13g2_buf_1
Xfanout579 _2895_/B input49/X VPWR VGND sg13g2_buf_1
X_4299_ _5344_/D _4255_/A hold801/X _4299_/S VPWR VGND sg13g2_mux2_1
X_3319_ _4427_/A _2578_/Y _4178_/A2 _3317_/Y _3318_/Y VPWR VGND sg13g2_a22oi_1
XFILLER_26_132 VPWR VGND sg13g2_decap_8
XFILLER_54_441 VPWR VGND sg13g2_decap_8
XFILLER_25_44 VPWR VGND sg13g2_decap_8
XFILLER_26_165 VPWR VGND sg13g2_decap_8
XFILLER_54_474 VPWR VGND sg13g2_decap_8
XFILLER_25_55 VPWR VGND sg13g2_fill_1
XFILLER_22_360 VPWR VGND sg13g2_decap_8
XFILLER_10_522 VPWR VGND sg13g2_decap_8
XFILLER_10_555 VPWR VGND sg13g2_decap_8
XFILLER_6_526 VPWR VGND sg13g2_decap_4
XFILLER_10_588 VPWR VGND sg13g2_decap_4
XFILLER_77_544 VPWR VGND sg13g2_decap_8
XFILLER_66_51 VPWR VGND sg13g2_decap_4
XFILLER_17_165 VPWR VGND sg13g2_decap_8
XFILLER_45_474 VPWR VGND sg13g2_decap_8
XFILLER_72_293 VPWR VGND sg13g2_decap_4
XFILLER_60_466 VPWR VGND sg13g2_decap_8
X_3670_ _3670_/Y _3670_/A _3670_/B _3670_/C _3670_/D VPWR VGND sg13g2_nand4_1
X_2621_ _2621_/Y _2621_/A VPWR VGND sg13g2_inv_1
X_5340_ _5340_/Q _5434_/CLK _5340_/D _5080_/Y VPWR VGND sg13g2_dfrbpq_1
Xoutput116 dmem_addr[26] _4628_/Y VPWR VGND sg13g2_buf_1
Xoutput105 dmem_addr[16] _4588_/Y VPWR VGND sg13g2_buf_1
X_2552_ _2552_/Y _2552_/A VPWR VGND sg13g2_inv_1
X_5271_ _5271_/Q _5425_/CLK _5271_/D _5011_/Y VPWR VGND sg13g2_dfrbpq_1
Xoutput149 dmem_wdata[26] _5462_/A VPWR VGND sg13g2_buf_1
Xoutput138 dmem_wdata[16] _5452_/A VPWR VGND sg13g2_buf_1
Xoutput127 dmem_addr[7] _4548_/Y VPWR VGND sg13g2_buf_1
XFILLER_5_592 VPWR VGND sg13g2_fill_2
XFILLER_5_581 VPWR VGND sg13g2_decap_8
X_4222_ _5403_/D _3068_/Y _4237_/S _4221_/Y VPWR VGND sg13g2_a21oi_1
X_4153_ _4153_/Y _4172_/A _4152_/Y _4171_/B1 VPWR VGND sg13g2_o21ai_1
XFILLER_68_544 VPWR VGND sg13g2_decap_8
X_4084_ _4084_/Y _4318_/A _2666_/C _4128_/A2 VPWR VGND sg13g2_a21oi_1
X_3104_ _3106_/C _2993_/A _3211_/B _4464_/A2 _2736_/Y VPWR VGND sg13g2_a22oi_1
X_3035_ _3228_/A _3253_/A _3026_/B _3269_/A _3033_/Y _3225_/B VPWR VGND sg13g2_a221oi_1
XFILLER_36_452 VPWR VGND sg13g2_decap_8
XFILLER_23_102 VPWR VGND sg13g2_decap_8
XFILLER_24_625 VPWR VGND sg13g2_decap_8
X_4986_ _4986_/Y _5148_/A VPWR VGND sg13g2_inv_1
X_3937_ _3937_/Y _4020_/A _3615_/X _4045_/A VPWR VGND sg13g2_o21ai_1
X_3868_ _3886_/A _3868_/A _3868_/B VPWR VGND sg13g2_or2_1
X_3799_ _3812_/A _3359_/Y _3703_/Y _3798_/Y VPWR VGND sg13g2_o21ai_1
X_2819_ _2823_/B _2819_/A _2819_/B VPWR VGND sg13g2_or2_1
Xfanout310 _4450_/C _3507_/A VPWR VGND sg13g2_buf_1
Xfanout321 _4128_/A2 output130/A VPWR VGND sg13g2_buf_1
Xfanout332 _4464_/A2 _3008_/Y VPWR VGND sg13g2_buf_1
XFILLER_78_319 VPWR VGND sg13g2_decap_4
Xfanout343 _3210_/B _2805_/Y VPWR VGND sg13g2_buf_1
Xfanout354 _4019_/B _3477_/Y VPWR VGND sg13g2_buf_1
Xfanout365 _4095_/A _4119_/A1 VPWR VGND sg13g2_buf_1
Xfanout376 _4435_/A _2770_/Y VPWR VGND sg13g2_buf_1
Xfanout387 _4146_/A2 _4176_/A1 VPWR VGND sg13g2_buf_1
Xfanout398 _4195_/A2 _4218_/A2 VPWR VGND sg13g2_buf_1
XFILLER_59_599 VPWR VGND sg13g2_decap_8
XFILLER_46_216 VPWR VGND sg13g2_decap_8
XFILLER_15_647 VPWR VGND sg13g2_fill_1
XFILLER_42_455 VPWR VGND sg13g2_decap_8
XFILLER_14_168 VPWR VGND sg13g2_decap_8
Xinput18 _2618_/A dmem_rdata[25] VPWR VGND sg13g2_buf_1
Xinput29 _2586_/A dmem_rdata[6] VPWR VGND sg13g2_buf_1
XFILLER_28_7 VPWR VGND sg13g2_decap_4
XFILLER_2_595 VPWR VGND sg13g2_fill_1
XFILLER_77_72 VPWR VGND sg13g2_fill_1
XFILLER_77_83 VPWR VGND sg13g2_fill_2
XFILLER_65_536 VPWR VGND sg13g2_decap_8
XFILLER_33_444 VPWR VGND sg13g2_decap_8
X_4840_ _4845_/D _4840_/A _4840_/B VPWR VGND sg13g2_xnor2_1
XFILLER_60_252 VPWR VGND sg13g2_decap_8
X_4771_ _4846_/A _4768_/A _4768_/B _4764_/Y VPWR VGND sg13g2_a21oi_1
X_3722_ _3722_/Y _3724_/A _3722_/B _3728_/B VPWR VGND sg13g2_nand3_1
X_3653_ _3896_/B _3895_/A _3654_/B VPWR VGND sg13g2_or2_1
X_2604_ _2604_/Y _2604_/A VPWR VGND sg13g2_inv_1
X_5323_ _5323_/Q _5421_/CLK _5323_/D _5063_/Y VPWR VGND sg13g2_dfrbpq_1
X_3584_ _3585_/D _5188_/Q _3637_/B _2817_/C VPWR VGND sg13g2_a21oi_1
X_5254_ _5254_/Q clkload5/A _5254_/D _4994_/Y VPWR VGND sg13g2_dfrbpq_1
X_5185_ _5185_/Q clkload5/A _5185_/D _4925_/Y VPWR VGND sg13g2_dfrbpq_1
X_4205_ _4205_/Y _2983_/Y _3748_/B _4204_/Y VPWR VGND sg13g2_a21oi_1
X_4136_ _4136_/Y _4211_/A2 _4158_/A _4116_/B _4209_/B1 VPWR VGND sg13g2_a22oi_1
XFILLER_68_374 VPWR VGND sg13g2_decap_4
XFILLER_56_514 VPWR VGND sg13g2_fill_1
X_4067_ _4067_/Y _4067_/A _4067_/B VPWR VGND sg13g2_nand2_1
XFILLER_71_506 VPWR VGND sg13g2_decap_8
XFILLER_56_558 VPWR VGND sg13g2_decap_8
X_3018_ _3018_/Y _3018_/A _3101_/A VPWR VGND sg13g2_nor2b_1
XFILLER_24_444 VPWR VGND sg13g2_fill_2
XFILLER_51_263 VPWR VGND sg13g2_decap_8
X_4969_ _4969_/Y _5001_/A VPWR VGND sg13g2_inv_1
XFILLER_22_34 VPWR VGND sg13g2_decap_8
XFILLER_22_89 VPWR VGND sg13g2_decap_8
XFILLER_3_337 VPWR VGND sg13g2_fill_1
XFILLER_3_348 VPWR VGND sg13g2_decap_8
XFILLER_59_385 VPWR VGND sg13g2_decap_8
XFILLER_47_569 VPWR VGND sg13g2_decap_8
XFILLER_74_366 VPWR VGND sg13g2_decap_8
XFILLER_15_422 VPWR VGND sg13g2_decap_8
XFILLER_27_293 VPWR VGND sg13g2_fill_2
XFILLER_55_591 VPWR VGND sg13g2_decap_8
XFILLER_42_263 VPWR VGND sg13g2_fill_2
XFILLER_63_85 VPWR VGND sg13g2_fill_1
XFILLER_30_436 VPWR VGND sg13g2_decap_8
XFILLER_42_274 VPWR VGND sg13g2_decap_8
XFILLER_6_120 VPWR VGND sg13g2_decap_8
XFILLER_6_164 VPWR VGND sg13g2_decap_8
XFILLER_78_650 VPWR VGND sg13g2_fill_2
XFILLER_38_525 VPWR VGND sg13g2_fill_2
XFILLER_65_311 VPWR VGND sg13g2_decap_4
XFILLER_38_569 VPWR VGND sg13g2_decap_8
XFILLER_25_219 VPWR VGND sg13g2_fill_1
XFILLER_53_528 VPWR VGND sg13g2_decap_8
XFILLER_21_414 VPWR VGND sg13g2_decap_8
XFILLER_33_296 VPWR VGND sg13g2_decap_8
X_4823_ _4833_/B _4823_/A _4823_/B _4848_/B VPWR VGND sg13g2_nand3_1
X_4754_ _4754_/Y _2573_/A _4741_/Y _4752_/Y VPWR VGND sg13g2_o21ai_1
X_3705_ _3706_/B _3359_/Y _3703_/Y _3704_/Y VPWR VGND sg13g2_a21oi_1
X_4685_ _4685_/X _5199_/Q _4693_/D _4684_/B VPWR VGND sg13g2_a21o_1
X_3636_ _3868_/A _3636_/A _3879_/C VPWR VGND sg13g2_xnor2_1
X_3567_ _4112_/B _3973_/C _3567_/B VPWR VGND sg13g2_nor2_1
X_5306_ _5306_/Q _5434_/CLK _5306_/D _5046_/Y VPWR VGND sg13g2_dfrbpq_1
XFILLER_68_19 VPWR VGND sg13g2_fill_2
X_5237_ _5237_/Q _5425_/CLK _5237_/D _4977_/Y VPWR VGND sg13g2_dfrbpq_1
X_3498_ _3502_/A _5250_/Q _3677_/B VPWR VGND sg13g2_nand2_1
X_5168_ _5168_/Y _5168_/A VPWR VGND sg13g2_inv_1
XFILLER_75_119 VPWR VGND sg13g2_fill_2
X_5099_ _5099_/Y _5135_/A VPWR VGND sg13g2_inv_1
X_4119_ _4119_/Y _4119_/A1 _4116_/B _3731_/A _3210_/A _4116_/Y VPWR VGND sg13g2_a221oi_1
XFILLER_68_193 VPWR VGND sg13g2_fill_1
XFILLER_17_34 VPWR VGND sg13g2_decap_4
XFILLER_71_336 VPWR VGND sg13g2_decap_4
XFILLER_52_550 VPWR VGND sg13g2_decap_8
XFILLER_12_414 VPWR VGND sg13g2_decap_4
XFILLER_33_11 VPWR VGND sg13g2_fill_1
XFILLER_12_458 VPWR VGND sg13g2_decap_4
XFILLER_33_44 VPWR VGND sg13g2_fill_1
XFILLER_33_55 VPWR VGND sg13g2_decap_4
XFILLER_8_418 VPWR VGND sg13g2_decap_8
XFILLER_4_602 VPWR VGND sg13g2_fill_2
XFILLER_4_624 VPWR VGND sg13g2_decap_8
XFILLER_3_189 VPWR VGND sg13g2_fill_2
XFILLER_66_108 VPWR VGND sg13g2_fill_1
XFILLER_47_311 VPWR VGND sg13g2_fill_1
XFILLER_66_119 VPWR VGND sg13g2_decap_4
XFILLER_47_355 VPWR VGND sg13g2_decap_8
XFILLER_47_366 VPWR VGND sg13g2_fill_1
XFILLER_74_51 VPWR VGND sg13g2_decap_8
XFILLER_28_580 VPWR VGND sg13g2_decap_4
XFILLER_74_95 VPWR VGND sg13g2_fill_1
XFILLER_74_185 VPWR VGND sg13g2_decap_8
XFILLER_50_509 VPWR VGND sg13g2_fill_2
XFILLER_43_594 VPWR VGND sg13g2_decap_8
XFILLER_30_233 VPWR VGND sg13g2_fill_2
XFILLER_30_255 VPWR VGND sg13g2_fill_2
X_4470_ _4472_/C _4470_/A _4470_/B _4470_/C _4470_/D VPWR VGND sg13g2_nor4_1
X_3421_ _4130_/B _3421_/A _3421_/B _3421_/C VPWR VGND sg13g2_nor3_1
XFILLER_7_495 VPWR VGND sg13g2_decap_8
X_3352_ _3353_/D _5293_/Q _3674_/B1 _3676_/B1 _5357_/Q VPWR VGND sg13g2_a22oi_1
X_3283_ _4470_/B _4133_/A _3270_/Y _3282_/Y VPWR VGND sg13g2_a21o_1
XFILLER_58_609 VPWR VGND sg13g2_fill_2
X_5022_ _5022_/Y _5152_/A VPWR VGND sg13g2_inv_1
XFILLER_66_631 VPWR VGND sg13g2_decap_8
XFILLER_17_0 VPWR VGND sg13g2_decap_4
XFILLER_38_333 VPWR VGND sg13g2_decap_8
XFILLER_38_344 VPWR VGND sg13g2_fill_1
XFILLER_26_528 VPWR VGND sg13g2_decap_8
XFILLER_19_591 VPWR VGND sg13g2_decap_8
XFILLER_26_539 VPWR VGND sg13g2_fill_2
XFILLER_53_347 VPWR VGND sg13g2_decap_8
XFILLER_34_561 VPWR VGND sg13g2_decap_8
XFILLER_21_211 VPWR VGND sg13g2_decap_4
XFILLER_21_233 VPWR VGND sg13g2_fill_1
X_4806_ _4823_/A _4807_/A _4814_/B VPWR VGND sg13g2_nand2_1
X_2998_ _2998_/Y _3011_/A _2730_/B _4188_/B2 VPWR VGND sg13g2_o21ai_1
XFILLER_21_299 VPWR VGND sg13g2_decap_4
X_4737_ _4737_/Y _4737_/A _4753_/A VPWR VGND sg13g2_xnor2_1
X_4668_ _4668_/Y _4691_/A _4668_/B VPWR VGND sg13g2_nor2_1
XFILLER_79_18 VPWR VGND sg13g2_fill_2
X_3619_ _3893_/A _3580_/A _3580_/B _3600_/A _3739_/A _3945_/A VPWR VGND sg13g2_a221oi_1
X_4599_ _4599_/Y _5455_/A _4618_/B2 _4598_/Y _4619_/B VPWR VGND sg13g2_a22oi_1
XFILLER_0_126 VPWR VGND sg13g2_fill_2
XFILLER_1_638 VPWR VGND sg13g2_decap_8
XFILLER_28_11 VPWR VGND sg13g2_fill_1
XFILLER_29_300 VPWR VGND sg13g2_decap_8
XFILLER_57_631 VPWR VGND sg13g2_decap_8
XFILLER_17_506 VPWR VGND sg13g2_decap_8
XFILLER_56_163 VPWR VGND sg13g2_decap_8
XFILLER_44_65 VPWR VGND sg13g2_decap_8
XFILLER_71_188 VPWR VGND sg13g2_fill_2
XFILLER_71_177 VPWR VGND sg13g2_decap_8
XFILLER_12_233 VPWR VGND sg13g2_fill_2
XFILLER_40_542 VPWR VGND sg13g2_fill_1
XFILLER_40_553 VPWR VGND sg13g2_fill_2
XFILLER_40_575 VPWR VGND sg13g2_fill_1
XFILLER_8_204 VPWR VGND sg13g2_decap_8
XFILLER_12_299 VPWR VGND sg13g2_decap_4
XFILLER_4_421 VPWR VGND sg13g2_fill_1
XFILLER_5_37 VPWR VGND sg13g2_decap_8
XFILLER_79_211 VPWR VGND sg13g2_decap_4
XFILLER_69_51 VPWR VGND sg13g2_decap_8
XFILLER_47_130 VPWR VGND sg13g2_decap_8
XFILLER_35_347 VPWR VGND sg13g2_decap_8
X_3970_ _3978_/C _4020_/A _3983_/B _3969_/Y VPWR VGND sg13g2_o21ai_1
XFILLER_62_166 VPWR VGND sg13g2_decap_8
XFILLER_50_328 VPWR VGND sg13g2_decap_8
X_2921_ _2923_/A _5432_/Q _2800_/B _3363_/A2 _5336_/Q VPWR VGND sg13g2_a22oi_1
X_2852_ _2852_/Y _5296_/Q _2920_/A2 _3004_/B1 _5392_/Q _2851_/X VPWR VGND sg13g2_a221oi_1
X_2783_ _2783_/Y _5430_/Q _2800_/B _3361_/B _5398_/Q _2782_/Y VPWR VGND sg13g2_a221oi_1
X_4522_ _4522_/Y _4520_/A _4519_/Y _4531_/A VPWR VGND sg13g2_o21ai_1
X_4453_ _4453_/Y _4451_/Y _4452_/Y _4443_/Y VPWR VGND sg13g2_a21oi_1
XFILLER_7_270 VPWR VGND sg13g2_decap_8
X_3404_ _3404_/Y _4206_/B _3406_/B VPWR VGND sg13g2_nand2_1
X_4384_ _5272_/D _3136_/Y hold750/X _4388_/S VPWR VGND sg13g2_mux2_1
X_3335_ _5467_/A _4641_/B VPWR VGND sg13g2_inv_1
X_3266_ _4355_/A _2584_/Y _4219_/A2 _3264_/Y _3265_/Y VPWR VGND sg13g2_a22oi_1
XFILLER_58_428 VPWR VGND sg13g2_decap_8
XFILLER_38_130 VPWR VGND sg13g2_decap_8
X_5005_ _5005_/Y _5112_/A VPWR VGND sg13g2_inv_1
X_3197_ _3197_/Y _4676_/A _3197_/A2 _4219_/A2 VPWR VGND sg13g2_a21oi_1
XFILLER_73_409 VPWR VGND sg13g2_fill_1
XFILLER_66_450 VPWR VGND sg13g2_decap_8
XFILLER_26_325 VPWR VGND sg13g2_fill_1
XFILLER_26_347 VPWR VGND sg13g2_fill_2
XFILLER_53_166 VPWR VGND sg13g2_fill_1
XFILLER_22_531 VPWR VGND sg13g2_decap_8
XFILLER_22_597 VPWR VGND sg13g2_decap_8
XFILLER_5_229 VPWR VGND sg13g2_fill_1
XFILLER_30_78 VPWR VGND sg13g2_decap_8
Xhold782 hold782/X _5273_/Q VPWR VGND sg13g2_dlygate4sd3_1
Xhold771 hold771/X _5320_/Q VPWR VGND sg13g2_dlygate4sd3_1
Xhold760 hold760/X _5389_/Q VPWR VGND sg13g2_dlygate4sd3_1
XFILLER_1_468 VPWR VGND sg13g2_decap_8
Xhold793 hold793/X _5407_/Q VPWR VGND sg13g2_dlygate4sd3_1
XFILLER_49_417 VPWR VGND sg13g2_decap_8
XFILLER_49_428 VPWR VGND sg13g2_fill_1
XFILLER_17_369 VPWR VGND sg13g2_decap_4
XFILLER_55_75 VPWR VGND sg13g2_decap_8
XFILLER_60_648 VPWR VGND sg13g2_decap_4
XFILLER_9_579 VPWR VGND sg13g2_decap_8
X_3120_ _3126_/A _3120_/A _3125_/B VPWR VGND sg13g2_nand2_1
XFILLER_67_225 VPWR VGND sg13g2_decap_8
X_3051_ _3095_/B _3411_/B _3051_/B VPWR VGND sg13g2_and2_1
XFILLER_63_442 VPWR VGND sg13g2_fill_1
XFILLER_63_486 VPWR VGND sg13g2_fill_2
X_3953_ _3953_/Y _2616_/Y _3953_/A2 _3951_/Y _3952_/Y VPWR VGND sg13g2_a22oi_1
X_3884_ _3885_/C _3884_/A _3884_/B _3884_/C VPWR VGND sg13g2_nand3_1
X_2904_ _2904_/Y _5267_/Q _3400_/A2 _3400_/B1 _5331_/Q _2903_/Y VPWR VGND sg13g2_a221oi_1
XFILLER_31_383 VPWR VGND sg13g2_fill_2
X_2835_ _2840_/A _5233_/Q _2938_/B VPWR VGND sg13g2_nand2_1
X_2766_ _2770_/B _5301_/Q _2920_/A2 _3361_/B _5397_/Q VPWR VGND sg13g2_a22oi_1
X_4505_ _5189_/D hold742/X _3908_/X _4509_/S VPWR VGND sg13g2_mux2_1
X_2697_ _2819_/B _2704_/C _2895_/C _2704_/B VPWR VGND sg13g2_nand3b_1
X_4436_ _4438_/C _4436_/A _4440_/B _4436_/C VPWR VGND sg13g2_nor3_1
Xfanout503 _3553_/B _2716_/X VPWR VGND sg13g2_buf_1
Xfanout514 _3456_/B _3547_/A2 VPWR VGND sg13g2_buf_1
X_4367_ _5288_/D _3932_/B hold756/X _4375_/S VPWR VGND sg13g2_mux2_1
Xfanout525 _5161_/A fanout533/X VPWR VGND sg13g2_buf_1
Xfanout536 _5150_/A _5149_/A VPWR VGND sg13g2_buf_1
Xfanout547 _5135_/A fanout550/X VPWR VGND sg13g2_buf_1
X_3318_ _3318_/Y _4524_/A _3318_/A2 _4178_/A2 VPWR VGND sg13g2_a21oi_1
XFILLER_76_19 VPWR VGND sg13g2_fill_1
Xfanout558 _5175_/A _5170_/A VPWR VGND sg13g2_buf_1
Xfanout569 _4959_/A input97/X VPWR VGND sg13g2_buf_1
X_4298_ _5345_/D _4253_/A hold703/X _4299_/S VPWR VGND sg13g2_mux2_1
XFILLER_27_601 VPWR VGND sg13g2_decap_8
X_3249_ _3249_/Y _3032_/X _3251_/B _4131_/A VPWR VGND sg13g2_a21oi_1
XFILLER_26_100 VPWR VGND sg13g2_decap_8
XFILLER_42_604 VPWR VGND sg13g2_fill_1
XFILLER_26_199 VPWR VGND sg13g2_fill_1
XFILLER_41_136 VPWR VGND sg13g2_decap_8
XFILLER_10_578 VPWR VGND sg13g2_fill_1
XFILLER_6_505 VPWR VGND sg13g2_decap_8
XFILLER_1_210 VPWR VGND sg13g2_fill_1
XFILLER_18_601 VPWR VGND sg13g2_decap_8
XFILLER_64_206 VPWR VGND sg13g2_decap_8
XFILLER_17_144 VPWR VGND sg13g2_fill_1
XFILLER_45_431 VPWR VGND sg13g2_decap_8
XFILLER_45_453 VPWR VGND sg13g2_fill_1
XFILLER_17_188 VPWR VGND sg13g2_fill_1
XFILLER_33_615 VPWR VGND sg13g2_decap_8
XFILLER_33_626 VPWR VGND sg13g2_fill_1
XFILLER_72_272 VPWR VGND sg13g2_decap_8
XFILLER_60_412 VPWR VGND sg13g2_fill_2
XFILLER_60_445 VPWR VGND sg13g2_decap_8
XFILLER_13_372 VPWR VGND sg13g2_decap_4
XFILLER_13_394 VPWR VGND sg13g2_fill_2
X_2620_ _2620_/Y _2620_/A VPWR VGND sg13g2_inv_1
XFILLER_9_376 VPWR VGND sg13g2_decap_4
Xoutput106 dmem_addr[17] _4592_/Y VPWR VGND sg13g2_buf_1
X_2551_ _2782_/A _2551_/A VPWR VGND sg13g2_inv_1
X_5270_ _5270_/Q _5425_/CLK _5270_/D _5010_/Y VPWR VGND sg13g2_dfrbpq_1
Xoutput139 dmem_wdata[17] _5453_/A VPWR VGND sg13g2_buf_1
Xoutput128 dmem_addr[8] _4552_/Y VPWR VGND sg13g2_buf_1
Xoutput117 dmem_addr[27] _4631_/X VPWR VGND sg13g2_buf_1
X_4221_ _4221_/Y _4221_/A _4237_/S VPWR VGND sg13g2_nor2_1
X_4152_ _4152_/Y _4152_/A _4152_/B VPWR VGND sg13g2_nor2_1
X_4083_ _4083_/X _2679_/X _4475_/A _4082_/Y VPWR VGND sg13g2_a21o_1
X_3103_ _3106_/B _4188_/A1 _3074_/A _4209_/A1 _4439_/A _3101_/Y VPWR VGND sg13g2_a221oi_1
X_3034_ _3034_/Y _3253_/A _3026_/B _3269_/A _3033_/Y VPWR VGND sg13g2_a22oi_1
XFILLER_55_217 VPWR VGND sg13g2_decap_8
XFILLER_36_486 VPWR VGND sg13g2_decap_8
XFILLER_51_401 VPWR VGND sg13g2_fill_1
XFILLER_51_456 VPWR VGND sg13g2_decap_8
X_4985_ _4985_/Y _5166_/A VPWR VGND sg13g2_inv_1
X_3936_ _3941_/A _3936_/A _3936_/B VPWR VGND sg13g2_nand2_1
X_3867_ _3868_/B _4041_/A _3863_/Y _3865_/X _3658_/Y VPWR VGND sg13g2_a22oi_1
X_3798_ _3798_/Y _3359_/Y _3703_/Y _3856_/A VPWR VGND sg13g2_a21oi_1
X_2818_ _2818_/Y _2818_/A _2818_/B VPWR VGND sg13g2_nor2_1
XFILLER_11_47 VPWR VGND sg13g2_decap_4
X_2749_ _2749_/Y _2749_/A _2749_/B _2749_/C _2749_/D VPWR VGND sg13g2_nand4_1
X_5399_ _5399_/Q _5432_/CLK _5399_/D _5139_/Y VPWR VGND sg13g2_dfrbpq_1
Xfanout300 _3847_/B _4449_/C VPWR VGND sg13g2_buf_1
Xfanout311 _3507_/A _3496_/Y VPWR VGND sg13g2_buf_1
Xfanout322 output130/A _3063_/Y VPWR VGND sg13g2_buf_1
X_4419_ _5239_/D _4346_/A hold684/X _4427_/B VPWR VGND sg13g2_mux2_1
Xfanout333 _4439_/C _2925_/Y VPWR VGND sg13g2_buf_1
Xfanout344 _3166_/A _4436_/A VPWR VGND sg13g2_buf_1
Xfanout355 _4448_/C _3477_/Y VPWR VGND sg13g2_buf_1
Xfanout366 _4209_/A1 _4119_/A1 VPWR VGND sg13g2_buf_1
XFILLER_59_556 VPWR VGND sg13g2_decap_4
Xfanout377 _3101_/A _4439_/A VPWR VGND sg13g2_buf_1
Xfanout388 _4176_/A1 _2680_/Y VPWR VGND sg13g2_buf_1
Xfanout399 _3197_/A2 _4218_/A2 VPWR VGND sg13g2_buf_1
XFILLER_59_578 VPWR VGND sg13g2_decap_8
XFILLER_27_453 VPWR VGND sg13g2_fill_2
XFILLER_14_147 VPWR VGND sg13g2_decap_8
XFILLER_10_342 VPWR VGND sg13g2_fill_2
XFILLER_22_191 VPWR VGND sg13g2_decap_8
Xinput19 input19/X dmem_rdata[26] VPWR VGND sg13g2_buf_1
XFILLER_52_87 VPWR VGND sg13g2_decap_8
XFILLER_6_335 VPWR VGND sg13g2_decap_8
XFILLER_77_51 VPWR VGND sg13g2_decap_8
XFILLER_77_95 VPWR VGND sg13g2_decap_8
XFILLER_65_515 VPWR VGND sg13g2_decap_8
XFILLER_80_507 VPWR VGND sg13g2_fill_2
XFILLER_52_209 VPWR VGND sg13g2_decap_8
XFILLER_18_497 VPWR VGND sg13g2_decap_4
XFILLER_45_283 VPWR VGND sg13g2_decap_4
XFILLER_73_592 VPWR VGND sg13g2_decap_8
XFILLER_60_231 VPWR VGND sg13g2_decap_8
X_4770_ _5208_/D _4814_/A _4768_/Y _4769_/Y VPWR VGND sg13g2_a21oi_1
X_3721_ _3728_/B _3721_/A _3721_/B _3721_/C _4208_/B VPWR VGND sg13g2_nor4_1
X_3652_ _3654_/B _3559_/S _4626_/B _3064_/A VPWR VGND sg13g2_a21oi_1
X_3583_ _3585_/C _5416_/Q _3508_/B _3583_/B1 _5288_/Q VPWR VGND sg13g2_a22oi_1
X_2603_ _2603_/Y _2603_/A VPWR VGND sg13g2_inv_1
X_5322_ _5322_/Q clkload2/A _5322_/D _5062_/Y VPWR VGND sg13g2_dfrbpq_1
XFILLER_47_0 VPWR VGND sg13g2_decap_8
XFILLER_5_390 VPWR VGND sg13g2_decap_8
X_5253_ _5253_/Q clkload5/A _5253_/D _4993_/Y VPWR VGND sg13g2_dfrbpq_1
X_5184_ _5184_/Q clkload6/A _5184_/D _4924_/Y VPWR VGND sg13g2_dfrbpq_1
X_4204_ _4204_/Y _4441_/A _4204_/B VPWR VGND sg13g2_nand2_1
X_4135_ _4135_/Y _4115_/B _4135_/B VPWR VGND sg13g2_nand2b_1
XFILLER_68_364 VPWR VGND sg13g2_fill_1
XFILLER_28_217 VPWR VGND sg13g2_decap_4
XFILLER_68_397 VPWR VGND sg13g2_decap_4
XFILLER_56_526 VPWR VGND sg13g2_decap_8
X_4066_ _4067_/B _4449_/A _3755_/D _4450_/C VPWR VGND sg13g2_o21ai_1
X_3017_ _3060_/C _4207_/A _2997_/X _3016_/Y VPWR VGND sg13g2_o21ai_1
XFILLER_71_529 VPWR VGND sg13g2_fill_1
XFILLER_64_581 VPWR VGND sg13g2_decap_8
XFILLER_51_242 VPWR VGND sg13g2_decap_8
X_4968_ _4968_/Y _5001_/A VPWR VGND sg13g2_inv_1
X_4899_ _5222_/D _4914_/A _4898_/X _4895_/Y VPWR VGND sg13g2_a21oi_1
X_3919_ _3927_/B _3919_/A _3919_/B _3919_/C VPWR VGND sg13g2_nor3_1
XFILLER_59_331 VPWR VGND sg13g2_decap_8
XFILLER_47_504 VPWR VGND sg13g2_decap_8
XFILLER_59_364 VPWR VGND sg13g2_decap_8
XFILLER_47_515 VPWR VGND sg13g2_fill_2
XFILLER_47_54 VPWR VGND sg13g2_decap_4
XFILLER_74_345 VPWR VGND sg13g2_decap_8
XFILLER_15_401 VPWR VGND sg13g2_decap_8
XFILLER_27_261 VPWR VGND sg13g2_decap_8
XFILLER_42_231 VPWR VGND sg13g2_decap_8
XFILLER_15_489 VPWR VGND sg13g2_decap_8
XFILLER_30_426 VPWR VGND sg13g2_fill_1
XFILLER_11_651 VPWR VGND sg13g2_fill_1
XFILLER_10_150 VPWR VGND sg13g2_fill_2
XFILLER_10_161 VPWR VGND sg13g2_decap_4
XFILLER_10_194 VPWR VGND sg13g2_fill_2
XFILLER_6_198 VPWR VGND sg13g2_decap_8
XFILLER_2_360 VPWR VGND sg13g2_fill_1
XFILLER_69_128 VPWR VGND sg13g2_decap_4
XFILLER_65_323 VPWR VGND sg13g2_decap_8
XFILLER_38_548 VPWR VGND sg13g2_decap_8
XFILLER_53_507 VPWR VGND sg13g2_decap_8
XFILLER_46_581 VPWR VGND sg13g2_fill_1
X_4822_ _4824_/B _4823_/A _4823_/B VPWR VGND sg13g2_nand2_1
XFILLER_61_584 VPWR VGND sg13g2_decap_8
X_4753_ _4753_/X _4753_/A _4753_/B VPWR VGND sg13g2_or2_1
X_3704_ _3704_/Y _3704_/A _3764_/A _5466_/A VPWR VGND sg13g2_nor3_1
X_4684_ _4694_/B _5199_/Q _4684_/B _4693_/D VPWR VGND sg13g2_nand3_1
X_3635_ _3635_/Y _3879_/B _3879_/C VPWR VGND sg13g2_nand2_1
X_3566_ _4062_/A _3973_/A _3566_/B VPWR VGND sg13g2_or2_1
X_5305_ _5305_/Q clkload9/A _5305_/D _5045_/Y VPWR VGND sg13g2_dfrbpq_1
X_3497_ _4065_/A _4450_/C VPWR VGND sg13g2_inv_1
X_5236_ _5236_/Q _5425_/CLK _5236_/D _4976_/Y VPWR VGND sg13g2_dfrbpq_1
X_5167_ _5167_/Y _5167_/A VPWR VGND sg13g2_inv_1
XFILLER_68_161 VPWR VGND sg13g2_fill_2
X_5098_ _5098_/Y _5158_/A VPWR VGND sg13g2_inv_1
X_4118_ _4123_/B _4045_/A _3541_/Y _4117_/Y VPWR VGND sg13g2_o21ai_1
XFILLER_56_356 VPWR VGND sg13g2_fill_1
X_4049_ _4049_/Y _3847_/A _4019_/B _4048_/Y VPWR VGND sg13g2_a21oi_1
XFILLER_37_581 VPWR VGND sg13g2_fill_1
XFILLER_37_592 VPWR VGND sg13g2_decap_8
XFILLER_52_540 VPWR VGND sg13g2_fill_1
XFILLER_52_595 VPWR VGND sg13g2_decap_8
XFILLER_24_297 VPWR VGND sg13g2_decap_8
XFILLER_20_481 VPWR VGND sg13g2_fill_1
XFILLER_3_102 VPWR VGND sg13g2_fill_2
XFILLER_3_113 VPWR VGND sg13g2_decap_8
XFILLER_58_53 VPWR VGND sg13g2_fill_1
XFILLER_59_150 VPWR VGND sg13g2_decap_4
XFILLER_47_334 VPWR VGND sg13g2_decap_8
XFILLER_74_164 VPWR VGND sg13g2_decap_8
XFILLER_15_253 VPWR VGND sg13g2_decap_4
XFILLER_15_286 VPWR VGND sg13g2_decap_8
XFILLER_30_201 VPWR VGND sg13g2_decap_8
XFILLER_43_573 VPWR VGND sg13g2_decap_8
XFILLER_11_492 VPWR VGND sg13g2_fill_2
X_3420_ _3421_/C _3020_/Y _3411_/C _3419_/Y VPWR VGND sg13g2_o21ai_1
X_3351_ _3353_/C _5389_/Q _3676_/A2 _2714_/B VPWR VGND sg13g2_a21oi_1
X_3282_ _3282_/Y _3268_/Y _3269_/Y _3281_/X VPWR VGND sg13g2_o21ai_1
X_5021_ _5021_/Y _5150_/A VPWR VGND sg13g2_inv_1
XFILLER_26_507 VPWR VGND sg13g2_decap_8
XFILLER_38_367 VPWR VGND sg13g2_decap_8
XFILLER_0_60 VPWR VGND sg13g2_decap_8
XFILLER_0_71 VPWR VGND sg13g2_decap_8
XFILLER_19_581 VPWR VGND sg13g2_fill_2
XFILLER_80_123 VPWR VGND sg13g2_fill_2
XFILLER_80_112 VPWR VGND sg13g2_fill_2
XFILLER_80_101 VPWR VGND sg13g2_fill_1
XFILLER_65_197 VPWR VGND sg13g2_decap_8
XFILLER_65_186 VPWR VGND sg13g2_fill_2
XFILLER_65_175 VPWR VGND sg13g2_decap_8
XFILLER_80_145 VPWR VGND sg13g2_fill_2
X_4805_ _4814_/B _4805_/A _4827_/D VPWR VGND sg13g2_xor2_1
X_2997_ _2997_/X _3011_/A _2997_/B VPWR VGND sg13g2_xor2_1
X_4736_ _4753_/A _4736_/A _4738_/B VPWR VGND sg13g2_xnor2_1
X_4667_ _4670_/B _4667_/A _4667_/B VPWR VGND sg13g2_xnor2_1
X_3618_ _3945_/A _3736_/B VPWR VGND sg13g2_inv_1
X_4598_ _4598_/Y _5455_/A _4598_/B VPWR VGND sg13g2_xnor2_1
XFILLER_0_105 VPWR VGND sg13g2_decap_8
X_3549_ _3552_/A _3549_/A _3549_/B _3549_/C VPWR VGND sg13g2_and3_1
XFILLER_0_138 VPWR VGND sg13g2_fill_2
X_5219_ _5219_/Q _5224_/CLK _5219_/D _4959_/Y VPWR VGND sg13g2_dfrbpq_1
XFILLER_29_334 VPWR VGND sg13g2_fill_2
XFILLER_28_67 VPWR VGND sg13g2_fill_1
XFILLER_72_635 VPWR VGND sg13g2_decap_8
XFILLER_71_112 VPWR VGND sg13g2_decap_8
XFILLER_44_11 VPWR VGND sg13g2_fill_2
XFILLER_44_22 VPWR VGND sg13g2_fill_1
XFILLER_71_156 VPWR VGND sg13g2_decap_8
XFILLER_12_212 VPWR VGND sg13g2_decap_8
XFILLER_40_521 VPWR VGND sg13g2_decap_8
XFILLER_52_381 VPWR VGND sg13g2_decap_4
XFILLER_52_392 VPWR VGND sg13g2_decap_4
XFILLER_40_598 VPWR VGND sg13g2_decap_8
XFILLER_8_249 VPWR VGND sg13g2_decap_8
XFILLER_60_65 VPWR VGND sg13g2_fill_1
XFILLER_69_85 VPWR VGND sg13g2_decap_4
XFILLER_75_440 VPWR VGND sg13g2_fill_2
Xclkbuf_2_3__f_clk clkbuf_2_3__f_clk/X clkbuf_0_clk/X VPWR VGND sg13g2_buf_16
XFILLER_75_473 VPWR VGND sg13g2_fill_1
XFILLER_75_462 VPWR VGND sg13g2_fill_2
XFILLER_62_123 VPWR VGND sg13g2_decap_4
XFILLER_62_101 VPWR VGND sg13g2_decap_8
XFILLER_16_584 VPWR VGND sg13g2_decap_8
XFILLER_50_307 VPWR VGND sg13g2_decap_8
X_2920_ _2925_/B _5304_/Q _2920_/A2 _3363_/B1 _5272_/Q VPWR VGND sg13g2_a22oi_1
XFILLER_43_381 VPWR VGND sg13g2_decap_8
X_2851_ _2851_/X _5424_/Q _2870_/B VPWR VGND sg13g2_and2_1
XFILLER_31_598 VPWR VGND sg13g2_decap_8
X_2782_ _2782_/Y _2782_/A _2819_/B VPWR VGND sg13g2_nor2_1
X_4521_ _4521_/Y _4521_/A _4521_/B _4521_/C VPWR VGND sg13g2_nand3_1
X_4452_ _4452_/Y _4452_/A _4452_/B _4452_/C _4452_/D VPWR VGND sg13g2_nand4_1
X_3403_ _3406_/B _2573_/A _5449_/A _3403_/S VPWR VGND sg13g2_mux2_1
X_4383_ _5273_/D _4224_/A hold782/X _4393_/S VPWR VGND sg13g2_mux2_1
X_3334_ _4641_/B _3333_/Y _3334_/B VPWR VGND sg13g2_nand2b_1
XFILLER_58_407 VPWR VGND sg13g2_decap_8
X_3265_ _3265_/Y _4652_/A _4218_/A2 _4219_/A2 VPWR VGND sg13g2_a21oi_1
XFILLER_38_120 VPWR VGND sg13g2_fill_1
X_5004_ _5004_/Y _5164_/A VPWR VGND sg13g2_inv_1
XFILLER_38_164 VPWR VGND sg13g2_decap_8
X_3196_ _3196_/X _3244_/A1 _4471_/A _3195_/Y VPWR VGND sg13g2_a21o_1
XFILLER_38_186 VPWR VGND sg13g2_decap_8
XFILLER_66_495 VPWR VGND sg13g2_decap_4
XFILLER_22_510 VPWR VGND sg13g2_decap_8
XFILLER_41_318 VPWR VGND sg13g2_decap_8
XFILLER_41_329 VPWR VGND sg13g2_fill_1
XFILLER_53_178 VPWR VGND sg13g2_fill_2
XFILLER_22_576 VPWR VGND sg13g2_decap_8
X_4719_ _4746_/D _4719_/A _4719_/B _4719_/C _4719_/D VPWR VGND sg13g2_nor4_1
XFILLER_30_57 VPWR VGND sg13g2_decap_8
Xhold750 hold750/X _5272_/Q VPWR VGND sg13g2_dlygate4sd3_1
Xhold772 hold772/X _5190_/Q VPWR VGND sg13g2_dlygate4sd3_1
Xhold761 hold761/X _5232_/Q VPWR VGND sg13g2_dlygate4sd3_1
Xhold794 hold794/X _5252_/Q VPWR VGND sg13g2_dlygate4sd3_1
Xhold783 hold783/X _5381_/Q VPWR VGND sg13g2_dlygate4sd3_1
XFILLER_39_66 VPWR VGND sg13g2_fill_2
XFILLER_29_120 VPWR VGND sg13g2_decap_8
XFILLER_39_77 VPWR VGND sg13g2_decap_8
XFILLER_76_237 VPWR VGND sg13g2_decap_4
XFILLER_29_131 VPWR VGND sg13g2_fill_2
XFILLER_57_440 VPWR VGND sg13g2_fill_1
XFILLER_17_326 VPWR VGND sg13g2_decap_4
XFILLER_57_473 VPWR VGND sg13g2_decap_8
XFILLER_17_348 VPWR VGND sg13g2_decap_8
XFILLER_72_443 VPWR VGND sg13g2_decap_8
XFILLER_72_498 VPWR VGND sg13g2_decap_8
XFILLER_60_627 VPWR VGND sg13g2_decap_8
XFILLER_13_543 VPWR VGND sg13g2_decap_8
XFILLER_9_558 VPWR VGND sg13g2_decap_8
XFILLER_71_97 VPWR VGND sg13g2_fill_1
X_3050_ _3051_/B _3046_/A _3046_/B _3047_/X VPWR VGND sg13g2_o21ai_1
XFILLER_48_462 VPWR VGND sg13g2_decap_4
XFILLER_75_281 VPWR VGND sg13g2_decap_8
XFILLER_63_410 VPWR VGND sg13g2_fill_2
XFILLER_51_605 VPWR VGND sg13g2_fill_1
XFILLER_63_465 VPWR VGND sg13g2_fill_2
XFILLER_63_454 VPWR VGND sg13g2_decap_8
XFILLER_51_649 VPWR VGND sg13g2_fill_2
X_3952_ _3952_/Y _2895_/B _3064_/A _3953_/A2 VPWR VGND sg13g2_a21oi_1
XFILLER_31_340 VPWR VGND sg13g2_fill_1
XFILLER_50_159 VPWR VGND sg13g2_decap_8
X_3883_ _3884_/C _3102_/A _3868_/A _3763_/B _3847_/A VPWR VGND sg13g2_a22oi_1
X_2903_ _2903_/Y _2552_/Y _3368_/B _3372_/B1 VPWR VGND sg13g2_o21ai_1
X_2834_ _2834_/Y _4434_/A _3026_/B VPWR VGND sg13g2_nand2_1
XFILLER_77_0 VPWR VGND sg13g2_decap_4
X_4504_ _5190_/D hold772/X _3890_/Y _4509_/S VPWR VGND sg13g2_mux2_1
X_2765_ _2770_/A _5333_/Q _3363_/A2 _3363_/B1 _5269_/Q VPWR VGND sg13g2_a22oi_1
XFILLER_8_580 VPWR VGND sg13g2_fill_2
X_2696_ _2696_/X _2895_/C _2696_/B VPWR VGND sg13g2_and2_1
XFILLER_6_70 VPWR VGND sg13g2_decap_8
X_4435_ _4438_/B _4435_/A _4435_/B _4439_/C _4439_/D VPWR VGND sg13g2_nor4_1
Xfanout504 _3692_/A2 _3401_/B1 VPWR VGND sg13g2_buf_1
Xfanout515 _2800_/B _2870_/B VPWR VGND sg13g2_buf_1
X_4366_ _5289_/D _3908_/X hold825/X _4371_/S VPWR VGND sg13g2_mux2_1
Xfanout526 _5160_/A _5153_/A VPWR VGND sg13g2_buf_1
Xfanout537 _5149_/A _5173_/A VPWR VGND sg13g2_buf_1
Xfanout548 _5166_/A fanout550/X VPWR VGND sg13g2_buf_1
X_3317_ _3317_/Y _4176_/A1 _4469_/B _3316_/Y VPWR VGND sg13g2_o21ai_1
Xfanout559 _5170_/A fanout565/X VPWR VGND sg13g2_buf_1
X_4297_ _5346_/D _4085_/Y hold689/X _4299_/S VPWR VGND sg13g2_mux2_1
X_3248_ _3251_/B _3248_/A _2834_/Y VPWR VGND sg13g2_nor2b_1
XFILLER_39_484 VPWR VGND sg13g2_decap_8
X_3179_ _4348_/A _2587_/Y _3246_/A2 _3177_/X _3178_/Y VPWR VGND sg13g2_a22oi_1
XFILLER_81_295 VPWR VGND sg13g2_fill_1
XFILLER_41_89 VPWR VGND sg13g2_decap_8
XFILLER_2_17 VPWR VGND sg13g2_decap_8
XFILLER_77_513 VPWR VGND sg13g2_fill_2
XFILLER_77_502 VPWR VGND sg13g2_decap_8
XFILLER_49_226 VPWR VGND sg13g2_fill_1
XFILLER_77_579 VPWR VGND sg13g2_decap_8
XFILLER_18_624 VPWR VGND sg13g2_fill_2
XFILLER_33_638 VPWR VGND sg13g2_decap_4
XFILLER_13_351 VPWR VGND sg13g2_fill_2
XFILLER_15_90 VPWR VGND sg13g2_fill_2
XFILLER_9_322 VPWR VGND sg13g2_fill_2
XFILLER_9_399 VPWR VGND sg13g2_decap_8
Xoutput107 dmem_addr[18] _4596_/Y VPWR VGND sg13g2_buf_1
X_2550_ _2550_/Y _2550_/A VPWR VGND sg13g2_inv_1
Xoutput129 dmem_addr[9] _4555_/Y VPWR VGND sg13g2_buf_1
Xoutput118 dmem_addr[28] _4634_/Y VPWR VGND sg13g2_buf_1
X_4220_ _5404_/D hold786/X _4261_/A _4236_/S VPWR VGND sg13g2_mux2_1
X_4151_ _4152_/B _3055_/B _3407_/X _3415_/Y VPWR VGND sg13g2_a21oi_1
X_4082_ _4082_/Y input75/X _3887_/B _3065_/B VPWR VGND sg13g2_o21ai_1
X_3102_ _3106_/A _3102_/A _3102_/B VPWR VGND sg13g2_nand2_1
X_3033_ _3033_/Y _3033_/A _3032_/B VPWR VGND sg13g2_nor2b_1
XFILLER_36_432 VPWR VGND sg13g2_fill_2
XFILLER_23_137 VPWR VGND sg13g2_decap_8
X_4984_ _4984_/Y _5112_/A VPWR VGND sg13g2_inv_1
XFILLER_63_295 VPWR VGND sg13g2_fill_2
X_3935_ _3935_/Y _3913_/B _3935_/B VPWR VGND sg13g2_nand2b_1
X_3866_ _3894_/A _4088_/B _3866_/B VPWR VGND sg13g2_nand2_1
X_3797_ _5422_/D hold656/X _3796_/Y _4013_/S VPWR VGND sg13g2_mux2_1
X_2817_ _2823_/A _5234_/Q _2895_/C _2817_/C VPWR VGND sg13g2_nand3_1
X_2748_ _2749_/D _5305_/Q _2920_/A2 _3004_/A2 _5337_/Q VPWR VGND sg13g2_a22oi_1
X_5467_ _5467_/X _5467_/A VPWR VGND sg13g2_buf_1
X_4418_ _5240_/D _3136_/Y hold657/X _4427_/B VPWR VGND sg13g2_mux2_1
X_2679_ _2679_/X _2999_/A _4523_/C VPWR VGND sg13g2_or2_1
X_5398_ _5398_/Q _5426_/CLK _5398_/D _5138_/Y VPWR VGND sg13g2_dfrbpq_1
Xfanout301 _4449_/C _3672_/Y VPWR VGND sg13g2_buf_1
Xfanout312 _3574_/A _3462_/Y VPWR VGND sg13g2_buf_1
Xfanout323 _3222_/B _3246_/A2 VPWR VGND sg13g2_buf_1
Xfanout334 _2993_/A _2925_/Y VPWR VGND sg13g2_buf_1
Xfanout345 _4436_/A _2787_/Y VPWR VGND sg13g2_buf_1
Xfanout356 _3756_/A _3426_/Y VPWR VGND sg13g2_buf_1
X_4349_ _5302_/D _2789_/A _4351_/B _4348_/Y VPWR VGND sg13g2_a21oi_1
XFILLER_59_535 VPWR VGND sg13g2_decap_8
Xfanout367 _3187_/B _4119_/A1 VPWR VGND sg13g2_buf_1
Xfanout378 _4439_/A _2749_/Y VPWR VGND sg13g2_buf_1
Xfanout389 _4462_/A _3120_/A VPWR VGND sg13g2_buf_1
XFILLER_74_538 VPWR VGND sg13g2_fill_2
XFILLER_36_45 VPWR VGND sg13g2_decap_8
XFILLER_14_104 VPWR VGND sg13g2_fill_1
XFILLER_15_627 VPWR VGND sg13g2_fill_1
XFILLER_27_487 VPWR VGND sg13g2_decap_4
XFILLER_36_56 VPWR VGND sg13g2_fill_2
XFILLER_14_126 VPWR VGND sg13g2_decap_8
XFILLER_42_424 VPWR VGND sg13g2_decap_8
XFILLER_22_170 VPWR VGND sg13g2_decap_8
XFILLER_10_321 VPWR VGND sg13g2_decap_8
XFILLER_6_314 VPWR VGND sg13g2_decap_8
XFILLER_6_369 VPWR VGND sg13g2_decap_8
XFILLER_7_0 VPWR VGND sg13g2_decap_8
XFILLER_2_586 VPWR VGND sg13g2_decap_8
XFILLER_77_85 VPWR VGND sg13g2_fill_1
XFILLER_37_218 VPWR VGND sg13g2_fill_2
XFILLER_18_443 VPWR VGND sg13g2_decap_8
XFILLER_18_476 VPWR VGND sg13g2_decap_8
XFILLER_45_262 VPWR VGND sg13g2_fill_2
XFILLER_60_210 VPWR VGND sg13g2_decap_8
XFILLER_33_468 VPWR VGND sg13g2_decap_8
X_3720_ _3720_/Y _3721_/A _4208_/B VPWR VGND sg13g2_nor2_1
XFILLER_60_287 VPWR VGND sg13g2_decap_8
XFILLER_41_490 VPWR VGND sg13g2_decap_8
X_3651_ _5462_/A _4626_/B VPWR VGND sg13g2_inv_1
XFILLER_9_163 VPWR VGND sg13g2_fill_1
X_3582_ _3585_/B _5320_/Q _3666_/B _3668_/A2 _5352_/Q VPWR VGND sg13g2_a22oi_1
X_2602_ _2602_/Y input9/X VPWR VGND sg13g2_inv_1
X_5321_ _5321_/Q clkload3/A _5321_/D _5061_/Y VPWR VGND sg13g2_dfrbpq_1
X_5252_ _5252_/Q clkload5/A _5252_/D _4992_/Y VPWR VGND sg13g2_dfrbpq_1
X_5183_ _5183_/Q _5414_/CLK _5183_/D _4923_/Y VPWR VGND sg13g2_dfrbpq_1
X_4203_ _4215_/B _4203_/A _4203_/B _4203_/C VPWR VGND sg13g2_nand3_1
XFILLER_68_310 VPWR VGND sg13g2_fill_1
X_4134_ _4135_/B _4160_/A _3752_/D _4143_/A VPWR VGND sg13g2_o21ai_1
XFILLER_68_343 VPWR VGND sg13g2_decap_8
XFILLER_56_505 VPWR VGND sg13g2_decap_8
X_4065_ _4065_/Y _4065_/A _4092_/B VPWR VGND sg13g2_xnor2_1
XFILLER_24_402 VPWR VGND sg13g2_decap_8
XFILLER_36_251 VPWR VGND sg13g2_fill_1
X_3016_ _3016_/Y _4433_/A _2997_/X _3015_/Y VPWR VGND sg13g2_a21oi_1
XFILLER_24_413 VPWR VGND sg13g2_fill_2
XFILLER_24_435 VPWR VGND sg13g2_fill_1
XFILLER_51_221 VPWR VGND sg13g2_decap_8
XFILLER_24_446 VPWR VGND sg13g2_fill_1
XFILLER_51_298 VPWR VGND sg13g2_decap_8
X_4967_ _4967_/Y _5001_/A VPWR VGND sg13g2_inv_1
X_4898_ _4898_/X _4905_/B _4898_/B VPWR VGND sg13g2_xor2_1
X_3918_ _3919_/C _4116_/A _3920_/A _3917_/Y VPWR VGND sg13g2_o21ai_1
X_3849_ _3849_/Y _3102_/A _3855_/B _3846_/Y _3697_/B _3848_/Y VPWR VGND sg13g2_a221oi_1
XFILLER_3_317 VPWR VGND sg13g2_decap_8
XFILLER_79_619 VPWR VGND sg13g2_fill_2
XFILLER_59_310 VPWR VGND sg13g2_fill_1
XFILLER_47_88 VPWR VGND sg13g2_decap_8
XFILLER_27_240 VPWR VGND sg13g2_decap_8
XFILLER_42_210 VPWR VGND sg13g2_decap_8
XFILLER_15_468 VPWR VGND sg13g2_fill_2
XFILLER_70_563 VPWR VGND sg13g2_decap_8
XFILLER_30_405 VPWR VGND sg13g2_decap_8
XFILLER_42_265 VPWR VGND sg13g2_fill_1
Xclkbuf_leaf_22_clk clkload3/A clkbuf_2_0__f_clk/X VPWR VGND sg13g2_buf_8
XFILLER_7_601 VPWR VGND sg13g2_decap_4
XFILLER_2_394 VPWR VGND sg13g2_fill_2
XFILLER_38_527 VPWR VGND sg13g2_fill_1
XFILLER_65_379 VPWR VGND sg13g2_fill_2
X_4821_ _4845_/B _4848_/B _4833_/A VPWR VGND sg13g2_nand2_1
XFILLER_21_427 VPWR VGND sg13g2_decap_8
XFILLER_14_490 VPWR VGND sg13g2_decap_8
Xclkbuf_leaf_13_clk _5392_/CLK clkbuf_2_3__f_clk/X VPWR VGND sg13g2_buf_8
X_4752_ _4752_/Y _4742_/A _4742_/B _4735_/Y VPWR VGND sg13g2_o21ai_1
X_4683_ _5199_/D _4691_/A hold863/X _4682_/Y VPWR VGND sg13g2_o21ai_1
X_3703_ _3703_/Y _3855_/A _3699_/Y _3702_/Y VPWR VGND sg13g2_o21ai_1
X_3634_ _3879_/C _3634_/A _5463_/A VPWR VGND sg13g2_nand2_1
X_3565_ _3580_/A _4130_/A _4130_/B _3564_/Y VPWR VGND sg13g2_a21o_1
X_5304_ _5304_/Q _5432_/CLK _5304_/D _5044_/Y VPWR VGND sg13g2_dfrbpq_1
X_3496_ _3496_/Y _3496_/A _3496_/B VPWR VGND sg13g2_nor2_1
X_5235_ _5235_/Q _5427_/CLK _5235_/D _4975_/Y VPWR VGND sg13g2_dfrbpq_1
XFILLER_68_140 VPWR VGND sg13g2_decap_8
XFILLER_29_505 VPWR VGND sg13g2_decap_8
X_5166_ _5166_/Y _5166_/A VPWR VGND sg13g2_inv_1
XFILLER_29_549 VPWR VGND sg13g2_decap_8
X_5097_ _5097_/Y _5129_/A VPWR VGND sg13g2_inv_1
X_4117_ _4117_/Y _4209_/B1 _4096_/B _4143_/A _4459_/A1 VPWR VGND sg13g2_a22oi_1
XFILLER_44_519 VPWR VGND sg13g2_decap_8
X_4048_ _4048_/Y _4048_/A _4048_/B VPWR VGND sg13g2_nor2_1
XFILLER_71_305 VPWR VGND sg13g2_fill_2
XFILLER_71_349 VPWR VGND sg13g2_fill_1
XFILLER_12_427 VPWR VGND sg13g2_decap_8
XFILLER_24_276 VPWR VGND sg13g2_decap_8
XFILLER_12_438 VPWR VGND sg13g2_fill_1
XFILLER_4_604 VPWR VGND sg13g2_fill_1
XFILLER_79_449 VPWR VGND sg13g2_decap_8
XFILLER_74_121 VPWR VGND sg13g2_decap_4
XFILLER_47_379 VPWR VGND sg13g2_decap_8
XFILLER_74_86 VPWR VGND sg13g2_decap_8
XFILLER_62_349 VPWR VGND sg13g2_fill_2
XFILLER_43_552 VPWR VGND sg13g2_decap_8
XFILLER_70_393 VPWR VGND sg13g2_decap_4
XFILLER_11_471 VPWR VGND sg13g2_decap_8
XFILLER_7_442 VPWR VGND sg13g2_fill_2
X_3350_ _3353_/B _5325_/Q _3674_/A2 _3689_/B1 _5421_/Q VPWR VGND sg13g2_a22oi_1
XFILLER_31_4 VPWR VGND sg13g2_decap_4
X_5020_ _5020_/Y _5156_/A VPWR VGND sg13g2_inv_1
X_3281_ _3281_/X _3281_/A _3281_/B _3281_/C _3281_/D VPWR VGND sg13g2_and4_1
Xclkbuf_leaf_2_clk clkload7/A clkbuf_leaf_3_clk/A VPWR VGND sg13g2_buf_8
XFILLER_66_622 VPWR VGND sg13g2_decap_4
XFILLER_78_493 VPWR VGND sg13g2_decap_8
XFILLER_19_571 VPWR VGND sg13g2_decap_4
XFILLER_81_625 VPWR VGND sg13g2_decap_8
XFILLER_53_327 VPWR VGND sg13g2_decap_8
XFILLER_80_135 VPWR VGND sg13g2_fill_1
XFILLER_21_246 VPWR VGND sg13g2_fill_2
XFILLER_34_596 VPWR VGND sg13g2_decap_8
X_4804_ _5212_/D _4814_/A _4803_/Y _4800_/Y VPWR VGND sg13g2_a21oi_1
X_4735_ _4735_/Y _4736_/A _4738_/B VPWR VGND sg13g2_nand2_1
X_2996_ _4206_/A _3011_/A _2997_/B VPWR VGND sg13g2_nor2_1
X_4666_ _4693_/D _5195_/Q _5196_/Q _5197_/Q _5198_/Q VPWR VGND sg13g2_and4_1
X_4597_ _4602_/B _5455_/A _4598_/B VPWR VGND sg13g2_nor2_1
X_3617_ _3736_/B _3615_/X _3617_/B VPWR VGND sg13g2_nand2b_1
X_3548_ _3549_/C _5311_/Q _3548_/A2 _3508_/B _5407_/Q VPWR VGND sg13g2_a22oi_1
XFILLER_1_618 VPWR VGND sg13g2_decap_4
X_3479_ _3479_/X _5184_/Q _3627_/B VPWR VGND sg13g2_and2_1
X_5218_ _5218_/Q _5224_/CLK _5218_/D _4958_/Y VPWR VGND sg13g2_dfrbpq_1
XFILLER_28_46 VPWR VGND sg13g2_decap_8
X_5149_ _5149_/Y _5149_/A VPWR VGND sg13g2_inv_1
XFILLER_29_368 VPWR VGND sg13g2_fill_2
XFILLER_72_603 VPWR VGND sg13g2_decap_4
XFILLER_44_338 VPWR VGND sg13g2_decap_8
XFILLER_71_102 VPWR VGND sg13g2_decap_4
XFILLER_40_511 VPWR VGND sg13g2_fill_2
XFILLER_40_566 VPWR VGND sg13g2_fill_1
XFILLER_4_434 VPWR VGND sg13g2_decap_4
XFILLER_4_456 VPWR VGND sg13g2_decap_8
XFILLER_4_467 VPWR VGND sg13g2_fill_1
XFILLER_4_489 VPWR VGND sg13g2_decap_8
XFILLER_0_651 VPWR VGND sg13g2_fill_1
XFILLER_67_419 VPWR VGND sg13g2_decap_8
XFILLER_35_305 VPWR VGND sg13g2_decap_8
XFILLER_47_165 VPWR VGND sg13g2_decap_8
XFILLER_75_485 VPWR VGND sg13g2_decap_8
XFILLER_18_90 VPWR VGND sg13g2_fill_2
XFILLER_43_360 VPWR VGND sg13g2_decap_8
XFILLER_31_544 VPWR VGND sg13g2_fill_2
X_2850_ _3270_/A _4439_/B _2850_/B VPWR VGND sg13g2_xnor2_1
X_2781_ _3184_/B _3187_/A _3040_/A VPWR VGND sg13g2_xnor2_1
X_4520_ _4619_/B _4520_/A _4520_/B VPWR VGND sg13g2_nor2_1
X_4451_ _4451_/Y _4451_/A _4451_/B _4451_/C _4451_/D VPWR VGND sg13g2_nand4_1
X_3402_ _5449_/A _3399_/Y _3400_/Y _3401_/Y VPWR VGND sg13g2_a21oi_1
X_4382_ _5274_/D _3093_/Y hold808/X _4388_/S VPWR VGND sg13g2_mux2_1
X_3333_ _3333_/Y _5262_/Q _2754_/A _2754_/B VPWR VGND sg13g2_a21oi_1
XFILLER_22_0 VPWR VGND sg13g2_decap_4
XFILLER_39_611 VPWR VGND sg13g2_decap_8
X_3264_ _3264_/Y _4146_/A2 _4470_/A _3263_/Y VPWR VGND sg13g2_o21ai_1
XFILLER_39_633 VPWR VGND sg13g2_fill_1
X_5003_ _5003_/Y _5164_/A VPWR VGND sg13g2_inv_1
X_3195_ _3195_/Y input93/X _3244_/A1 _3065_/B VPWR VGND sg13g2_o21ai_1
XFILLER_53_102 VPWR VGND sg13g2_fill_2
XFILLER_53_135 VPWR VGND sg13g2_fill_2
XFILLER_34_382 VPWR VGND sg13g2_decap_8
XFILLER_34_393 VPWR VGND sg13g2_fill_1
XFILLER_14_59 VPWR VGND sg13g2_decap_8
XFILLER_22_555 VPWR VGND sg13g2_decap_8
XFILLER_61_190 VPWR VGND sg13g2_decap_8
X_2979_ _4442_/A _4435_/A _4436_/A _4435_/B _4436_/C VPWR VGND sg13g2_nand4_1
X_4718_ _5203_/D _4745_/S _4716_/X _4717_/Y VPWR VGND sg13g2_a21oi_1
X_4649_ _4652_/B _4649_/A _4649_/B VPWR VGND sg13g2_xor2_1
Xhold740 hold740/X _5355_/Q VPWR VGND sg13g2_dlygate4sd3_1
Xhold751 hold751/X _5378_/Q VPWR VGND sg13g2_dlygate4sd3_1
Xhold773 hold773/X _5180_/Q VPWR VGND sg13g2_dlygate4sd3_1
Xhold762 hold762/X _5388_/Q VPWR VGND sg13g2_dlygate4sd3_1
Xhold795 hold795/X _5282_/Q VPWR VGND sg13g2_dlygate4sd3_1
Xhold784 hold784/X _5284_/Q VPWR VGND sg13g2_dlygate4sd3_1
XFILLER_76_216 VPWR VGND sg13g2_decap_8
XFILLER_76_249 VPWR VGND sg13g2_decap_4
XFILLER_17_305 VPWR VGND sg13g2_decap_8
XFILLER_29_165 VPWR VGND sg13g2_fill_2
XFILLER_72_477 VPWR VGND sg13g2_decap_8
XFILLER_13_522 VPWR VGND sg13g2_decap_8
XFILLER_13_577 VPWR VGND sg13g2_decap_4
XFILLER_40_352 VPWR VGND sg13g2_fill_2
XFILLER_40_374 VPWR VGND sg13g2_decap_8
XFILLER_9_537 VPWR VGND sg13g2_decap_8
XFILLER_36_625 VPWR VGND sg13g2_fill_2
XFILLER_35_124 VPWR VGND sg13g2_decap_8
XFILLER_35_135 VPWR VGND sg13g2_fill_1
XFILLER_35_146 VPWR VGND sg13g2_fill_2
XFILLER_35_179 VPWR VGND sg13g2_fill_1
XFILLER_51_628 VPWR VGND sg13g2_decap_8
X_3951_ _3951_/Y _3858_/A _4477_/B _3950_/Y VPWR VGND sg13g2_o21ai_1
XFILLER_63_488 VPWR VGND sg13g2_fill_1
XFILLER_16_382 VPWR VGND sg13g2_fill_1
X_2902_ _2902_/Y _5427_/Q _3397_/B _3399_/B1 _5395_/Q _2901_/Y VPWR VGND sg13g2_a221oi_1
X_3882_ _3884_/B _4211_/B2 _4446_/C _3895_/A _4459_/A1 VPWR VGND sg13g2_a22oi_1
XFILLER_31_363 VPWR VGND sg13g2_decap_8
X_2833_ _3248_/A _4434_/A _3026_/B VPWR VGND sg13g2_nor2_1
X_2764_ _2764_/Y _3081_/B _3102_/B VPWR VGND sg13g2_nand2b_1
X_4503_ _5191_/D hold830/X _3860_/Y _4509_/S VPWR VGND sg13g2_mux2_1
XFILLER_8_592 VPWR VGND sg13g2_decap_8
X_2695_ _2696_/B _2704_/C _2704_/B VPWR VGND sg13g2_nor2b_1
X_4434_ _4434_/Y _4434_/A _4439_/B _4440_/C _4444_/B VPWR VGND sg13g2_nor4_1
Xfanout505 _2754_/B _3401_/B1 VPWR VGND sg13g2_buf_1
X_4365_ _5290_/D _3890_/Y hold835/X _4371_/S VPWR VGND sg13g2_mux2_1
Xfanout516 _2870_/B _3547_/A2 VPWR VGND sg13g2_buf_1
Xfanout527 _5153_/A fanout533/X VPWR VGND sg13g2_buf_1
Xfanout538 _5173_/A fanout545/X VPWR VGND sg13g2_buf_1
X_3316_ _3316_/Y _2577_/Y _4146_/A2 _4195_/A2 VPWR VGND sg13g2_a21oi_1
Xfanout549 _5167_/A fanout550/X VPWR VGND sg13g2_buf_1
X_4296_ _5347_/D _4059_/Y hold705/X _4299_/S VPWR VGND sg13g2_mux2_1
X_3247_ _5427_/D hold710/X _4353_/A _4518_/S VPWR VGND sg13g2_mux2_1
X_3178_ _3178_/Y _4688_/A _3197_/A2 _3246_/A2 VPWR VGND sg13g2_a21oi_1
XFILLER_54_400 VPWR VGND sg13g2_decap_8
XFILLER_26_146 VPWR VGND sg13g2_fill_2
XFILLER_54_455 VPWR VGND sg13g2_fill_2
XFILLER_14_319 VPWR VGND sg13g2_decap_8
XFILLER_26_179 VPWR VGND sg13g2_decap_4
XFILLER_42_639 VPWR VGND sg13g2_decap_4
XFILLER_22_330 VPWR VGND sg13g2_decap_8
XFILLER_22_374 VPWR VGND sg13g2_decap_4
XFILLER_10_569 VPWR VGND sg13g2_decap_8
XFILLER_41_35 VPWR VGND sg13g2_fill_2
XFILLER_41_46 VPWR VGND sg13g2_decap_8
XFILLER_41_68 VPWR VGND sg13g2_decap_8
XFILLER_77_558 VPWR VGND sg13g2_decap_4
XFILLER_17_102 VPWR VGND sg13g2_decap_4
XFILLER_66_65 VPWR VGND sg13g2_decap_8
XFILLER_57_271 VPWR VGND sg13g2_fill_2
XFILLER_17_135 VPWR VGND sg13g2_decap_8
XFILLER_17_179 VPWR VGND sg13g2_decap_8
XFILLER_45_488 VPWR VGND sg13g2_decap_8
XFILLER_60_403 VPWR VGND sg13g2_decap_4
XFILLER_13_330 VPWR VGND sg13g2_fill_1
XFILLER_15_80 VPWR VGND sg13g2_fill_1
XFILLER_13_396 VPWR VGND sg13g2_fill_1
XFILLER_70_8 VPWR VGND sg13g2_fill_2
XFILLER_63_7 VPWR VGND sg13g2_decap_8
Xoutput119 dmem_addr[29] _4637_/Y VPWR VGND sg13g2_buf_1
Xoutput108 dmem_addr[19] _4600_/Y VPWR VGND sg13g2_buf_1
XFILLER_5_562 VPWR VGND sg13g2_decap_4
X_4150_ _5407_/D hold793/X _4335_/A _4179_/S VPWR VGND sg13g2_mux2_1
X_3101_ _3101_/Y _3101_/A _3166_/B VPWR VGND sg13g2_nor2_1
X_4081_ _4475_/A _4081_/A _4081_/B _4081_/C VPWR VGND sg13g2_nor3_1
XFILLER_68_558 VPWR VGND sg13g2_decap_8
X_3032_ _3032_/X _3269_/A _3032_/B VPWR VGND sg13g2_and2_1
XFILLER_48_282 VPWR VGND sg13g2_decap_4
XFILLER_36_466 VPWR VGND sg13g2_decap_4
XFILLER_23_116 VPWR VGND sg13g2_decap_8
XFILLER_24_639 VPWR VGND sg13g2_decap_8
XFILLER_51_436 VPWR VGND sg13g2_fill_1
X_4983_ _4983_/Y _5145_/A VPWR VGND sg13g2_inv_1
X_3934_ _3935_/B _4448_/B _3996_/A _3942_/A VPWR VGND sg13g2_o21ai_1
X_3865_ _3865_/X _4088_/B _3866_/B VPWR VGND sg13g2_and2_1
X_2816_ _3204_/A _2992_/B _3210_/C VPWR VGND sg13g2_xnor2_1
X_3796_ _3796_/Y _2622_/Y _3889_/B _3794_/X _3795_/Y VPWR VGND sg13g2_a22oi_1
X_2747_ _2749_/C _5369_/Q _3003_/A2 _3003_/B1 _5273_/Q VPWR VGND sg13g2_a22oi_1
X_5466_ _5466_/X _5466_/A VPWR VGND sg13g2_buf_1
X_2678_ _4523_/C _2653_/B _2678_/B _2678_/C VPWR VGND sg13g2_nand3b_1
X_4417_ _5241_/D _4224_/A hold682/X _4424_/S VPWR VGND sg13g2_mux2_1
X_5397_ _5397_/Q _5435_/CLK _5397_/D _5137_/Y VPWR VGND sg13g2_dfrbpq_1
Xfanout302 _3895_/A _3642_/Y VPWR VGND sg13g2_buf_1
Xfanout313 _4450_/B _3462_/Y VPWR VGND sg13g2_buf_1
Xfanout324 _3246_/A2 _4219_/A2 VPWR VGND sg13g2_buf_1
Xfanout335 _3233_/A _4440_/C VPWR VGND sg13g2_buf_1
Xfanout346 _4618_/B2 _4580_/B VPWR VGND sg13g2_buf_1
Xfanout357 _4450_/A _3426_/Y VPWR VGND sg13g2_buf_1
X_4348_ _4348_/Y _4348_/A _4351_/B VPWR VGND sg13g2_nor2_1
Xfanout368 _4119_/A1 _2959_/X VPWR VGND sg13g2_buf_1
Xfanout379 _4441_/C _2736_/Y VPWR VGND sg13g2_buf_1
X_4279_ _5361_/D _2554_/Y _4280_/B _4278_/Y VPWR VGND sg13g2_o21ai_1
XFILLER_27_422 VPWR VGND sg13g2_decap_8
XFILLER_67_591 VPWR VGND sg13g2_decap_8
XFILLER_15_606 VPWR VGND sg13g2_decap_8
XFILLER_42_403 VPWR VGND sg13g2_decap_8
XFILLER_42_447 VPWR VGND sg13g2_fill_2
XFILLER_42_469 VPWR VGND sg13g2_decap_8
XFILLER_10_300 VPWR VGND sg13g2_decap_8
XFILLER_52_45 VPWR VGND sg13g2_decap_4
XFILLER_10_344 VPWR VGND sg13g2_fill_1
XFILLER_52_67 VPWR VGND sg13g2_decap_4
XFILLER_10_366 VPWR VGND sg13g2_decap_8
XFILLER_6_348 VPWR VGND sg13g2_decap_8
XFILLER_2_521 VPWR VGND sg13g2_decap_8
XFILLER_2_532 VPWR VGND sg13g2_fill_1
XFILLER_2_543 VPWR VGND sg13g2_fill_2
XFILLER_77_366 VPWR VGND sg13g2_fill_1
XFILLER_33_403 VPWR VGND sg13g2_decap_8
XFILLER_21_609 VPWR VGND sg13g2_fill_1
XFILLER_33_458 VPWR VGND sg13g2_decap_4
XFILLER_60_266 VPWR VGND sg13g2_decap_8
XFILLER_9_142 VPWR VGND sg13g2_decap_8
X_3650_ _4626_/B _3649_/Y _3650_/B VPWR VGND sg13g2_nand2b_1
X_3581_ _3585_/A _5384_/Q _3581_/B VPWR VGND sg13g2_nand2_1
X_2601_ _2601_/Y _2601_/A VPWR VGND sg13g2_inv_1
X_5320_ _5320_/Q clkload1/A _5320_/D _5060_/Y VPWR VGND sg13g2_dfrbpq_1
X_5251_ _5251_/Q _5414_/CLK _5251_/D _4991_/Y VPWR VGND sg13g2_dfrbpq_1
X_4202_ _4203_/C _4201_/A _4201_/B _4201_/C VPWR VGND sg13g2_a21o_1
X_5182_ _5182_/Q clkload7/A _5182_/D _4922_/Y VPWR VGND sg13g2_dfrbpq_1
X_4133_ _4145_/B _4133_/A _4133_/B _4133_/C VPWR VGND sg13g2_nand3_1
X_4064_ _4081_/A _3714_/A _4062_/X _4063_/Y VPWR VGND sg13g2_a21oi_1
X_3015_ _3015_/Y _3015_/A _3015_/B _3015_/C VPWR VGND sg13g2_nand3_1
XFILLER_64_561 VPWR VGND sg13g2_fill_1
XFILLER_64_550 VPWR VGND sg13g2_decap_8
XFILLER_51_200 VPWR VGND sg13g2_decap_4
XFILLER_12_609 VPWR VGND sg13g2_fill_2
XFILLER_51_277 VPWR VGND sg13g2_decap_8
X_4966_ _4966_/Y _5076_/A VPWR VGND sg13g2_inv_1
XFILLER_32_480 VPWR VGND sg13g2_fill_2
X_4897_ _4898_/B _4904_/A _4889_/B _4892_/B VPWR VGND sg13g2_o21ai_1
X_3917_ _3917_/Y _3938_/A _3920_/A _3938_/B _3936_/A VPWR VGND sg13g2_a22oi_1
XFILLER_22_48 VPWR VGND sg13g2_fill_2
X_3848_ _3848_/Y _4116_/A _3763_/B _3847_/Y VPWR VGND sg13g2_o21ai_1
X_3779_ _3844_/B _4452_/A _3878_/B VPWR VGND sg13g2_and2_1
X_5449_ _5449_/X _5449_/A VPWR VGND sg13g2_buf_1
XFILLER_47_528 VPWR VGND sg13g2_decap_8
XFILLER_47_78 VPWR VGND sg13g2_fill_1
XFILLER_59_399 VPWR VGND sg13g2_decap_8
XFILLER_62_509 VPWR VGND sg13g2_fill_2
XFILLER_15_436 VPWR VGND sg13g2_decap_8
XFILLER_63_33 VPWR VGND sg13g2_decap_8
XFILLER_42_288 VPWR VGND sg13g2_decap_8
XFILLER_70_586 VPWR VGND sg13g2_fill_2
XFILLER_63_99 VPWR VGND sg13g2_fill_2
XFILLER_11_642 VPWR VGND sg13g2_decap_8
XFILLER_10_130 VPWR VGND sg13g2_fill_2
XFILLER_10_196 VPWR VGND sg13g2_fill_1
XFILLER_12_81 VPWR VGND sg13g2_fill_2
XFILLER_6_178 VPWR VGND sg13g2_fill_1
XFILLER_2_351 VPWR VGND sg13g2_decap_8
XFILLER_2_373 VPWR VGND sg13g2_decap_8
XFILLER_46_550 VPWR VGND sg13g2_decap_8
XFILLER_33_211 VPWR VGND sg13g2_decap_8
X_4820_ _4833_/A _4831_/A _4820_/B VPWR VGND sg13g2_nand2_1
XFILLER_73_391 VPWR VGND sg13g2_decap_8
XFILLER_61_553 VPWR VGND sg13g2_decap_8
X_4751_ _4756_/B _4749_/A _4751_/B VPWR VGND sg13g2_nand2b_1
X_4682_ _4682_/Y _4691_/A _4682_/B VPWR VGND sg13g2_nand2_1
X_3702_ _3702_/Y _3829_/B _3820_/B _3700_/Y VPWR VGND sg13g2_a21oi_1
X_3633_ _5463_/A _4629_/B _4629_/C VPWR VGND sg13g2_nor2_1
XFILLER_52_0 VPWR VGND sg13g2_decap_8
X_3564_ _3564_/Y _3564_/A _3564_/B _4112_/A _3731_/B VPWR VGND sg13g2_nand4_1
X_5303_ _5303_/Q _5425_/CLK _5303_/D _5043_/Y VPWR VGND sg13g2_dfrbpq_1
X_3495_ _3496_/B _5250_/Q _2694_/B _3671_/B1 VPWR VGND sg13g2_a21oi_1
X_5234_ _5234_/Q clkload9/A _5234_/D _4974_/Y VPWR VGND sg13g2_dfrbpq_1
X_5165_ _5165_/Y _5174_/A VPWR VGND sg13g2_inv_1
XFILLER_29_528 VPWR VGND sg13g2_decap_4
X_4116_ _4116_/Y _4116_/A _4116_/B VPWR VGND sg13g2_nor2_1
X_5096_ _5096_/Y _5125_/A VPWR VGND sg13g2_inv_1
X_4047_ _4051_/B _3879_/A _4029_/A _4046_/Y VPWR VGND sg13g2_o21ai_1
XFILLER_37_572 VPWR VGND sg13g2_fill_2
XFILLER_52_575 VPWR VGND sg13g2_fill_1
XFILLER_52_564 VPWR VGND sg13g2_decap_8
X_4949_ _4949_/Y _4951_/A VPWR VGND sg13g2_inv_1
XFILLER_20_494 VPWR VGND sg13g2_fill_1
XFILLER_4_638 VPWR VGND sg13g2_decap_8
XFILLER_3_137 VPWR VGND sg13g2_fill_1
XFILLER_58_22 VPWR VGND sg13g2_decap_8
XFILLER_75_601 VPWR VGND sg13g2_decap_8
XFILLER_58_88 VPWR VGND sg13g2_decap_8
XFILLER_59_185 VPWR VGND sg13g2_fill_2
XFILLER_35_509 VPWR VGND sg13g2_decap_8
XFILLER_15_211 VPWR VGND sg13g2_decap_8
XFILLER_74_65 VPWR VGND sg13g2_decap_8
XFILLER_7_421 VPWR VGND sg13g2_decap_8
XFILLER_7_465 VPWR VGND sg13g2_decap_8
X_3280_ _3281_/D _4139_/A1 _2849_/Y _4209_/B1 _4434_/A _3275_/Y VPWR VGND sg13g2_a221oi_1
XFILLER_24_4 VPWR VGND sg13g2_decap_8
XFILLER_65_111 VPWR VGND sg13g2_fill_1
XFILLER_19_550 VPWR VGND sg13g2_decap_8
XFILLER_81_604 VPWR VGND sg13g2_decap_8
XFILLER_34_575 VPWR VGND sg13g2_decap_8
XFILLER_21_225 VPWR VGND sg13g2_fill_2
X_4803_ _4803_/Y _4803_/A _4808_/D VPWR VGND sg13g2_xnor2_1
XFILLER_21_258 VPWR VGND sg13g2_fill_1
X_4734_ _4738_/B _4734_/A _4746_/D VPWR VGND sg13g2_xor2_1
X_2995_ _2997_/B _3773_/A _3750_/B VPWR VGND sg13g2_nand2_1
XFILLER_9_82 VPWR VGND sg13g2_decap_8
X_4665_ _5197_/D _4691_/A hold855/X _4664_/Y VPWR VGND sg13g2_o21ai_1
X_4596_ _4596_/Y _4623_/C _4594_/Y _4595_/Y VPWR VGND sg13g2_o21ai_1
X_3616_ _3617_/B _3938_/B _3659_/B VPWR VGND sg13g2_or2_1
X_3547_ _3549_/B _5179_/Q _3547_/A2 _3547_/B1 _5375_/Q VPWR VGND sg13g2_a22oi_1
X_3478_ _3478_/Y _4019_/B VPWR VGND sg13g2_inv_1
X_5217_ _5217_/Q _5224_/CLK _5217_/D _4957_/Y VPWR VGND sg13g2_dfrbpq_1
XFILLER_28_25 VPWR VGND sg13g2_decap_4
XFILLER_29_314 VPWR VGND sg13g2_decap_8
X_5148_ _5148_/Y _5148_/A VPWR VGND sg13g2_inv_1
XFILLER_69_494 VPWR VGND sg13g2_decap_8
XFILLER_57_645 VPWR VGND sg13g2_fill_2
XFILLER_29_347 VPWR VGND sg13g2_decap_8
X_5079_ _5079_/Y _5168_/A VPWR VGND sg13g2_inv_1
XFILLER_56_177 VPWR VGND sg13g2_decap_8
XFILLER_37_391 VPWR VGND sg13g2_fill_1
XFILLER_12_269 VPWR VGND sg13g2_fill_1
XFILLER_8_218 VPWR VGND sg13g2_decap_8
XFILLER_60_78 VPWR VGND sg13g2_decap_4
XFILLER_4_402 VPWR VGND sg13g2_decap_8
XFILLER_0_630 VPWR VGND sg13g2_fill_1
XFILLER_79_258 VPWR VGND sg13g2_fill_1
XFILLER_47_144 VPWR VGND sg13g2_decap_8
XFILLER_47_188 VPWR VGND sg13g2_decap_8
XFILLER_31_523 VPWR VGND sg13g2_decap_8
X_2780_ _3182_/A _3187_/A _3040_/A VPWR VGND sg13g2_xor2_1
X_4450_ _4451_/D _4450_/A _4450_/B _4450_/C _4450_/D VPWR VGND sg13g2_nor4_1
X_4381_ _5275_/D _3068_/Y _4388_/S _4380_/Y VPWR VGND sg13g2_o21ai_1
X_3401_ _3401_/Y _5244_/Q _3401_/A2 _3401_/B1 VPWR VGND sg13g2_a21oi_1
X_3332_ _3334_/B _3332_/A _3332_/B _3332_/C _3332_/D VPWR VGND sg13g2_nand4_1
XFILLER_3_490 VPWR VGND sg13g2_decap_4
X_3263_ _3263_/Y _2583_/Y _4146_/A2 _4218_/A2 VPWR VGND sg13g2_a21oi_1
XFILLER_39_645 VPWR VGND sg13g2_fill_2
X_5002_ _5002_/Y _5158_/A VPWR VGND sg13g2_inv_1
X_3194_ _4471_/A _3269_/B _3181_/Y _3182_/Y _4133_/A _3193_/Y VPWR VGND sg13g2_a221oi_1
XFILLER_15_0 VPWR VGND sg13g2_decap_8
XFILLER_66_464 VPWR VGND sg13g2_decap_4
XFILLER_54_604 VPWR VGND sg13g2_decap_8
XFILLER_66_475 VPWR VGND sg13g2_fill_1
XFILLER_54_637 VPWR VGND sg13g2_fill_2
XFILLER_53_114 VPWR VGND sg13g2_decap_8
XFILLER_34_361 VPWR VGND sg13g2_decap_8
X_2978_ _2981_/D _4435_/A _4436_/A _4435_/B _4436_/C VPWR VGND sg13g2_and4_1
X_4717_ _4717_/Y _4745_/S _4717_/B VPWR VGND sg13g2_nor2_1
XFILLER_30_37 VPWR VGND sg13g2_decap_8
X_4648_ _4648_/Y _4649_/A _4664_/A _4647_/Y VPWR VGND sg13g2_o21ai_1
Xhold730 hold730/X _5258_/Q VPWR VGND sg13g2_dlygate4sd3_1
Xhold741 hold741/X _5409_/Q VPWR VGND sg13g2_dlygate4sd3_1
Xhold752 hold752/X _5417_/Q VPWR VGND sg13g2_dlygate4sd3_1
Xhold763 hold763/X _5353_/Q VPWR VGND sg13g2_dlygate4sd3_1
X_4579_ _4579_/Y _4577_/Y _4579_/B VPWR VGND sg13g2_nand2b_1
Xhold796 hold796/X _5262_/Q VPWR VGND sg13g2_dlygate4sd3_1
Xhold785 hold785/X _5382_/Q VPWR VGND sg13g2_dlygate4sd3_1
Xhold774 hold774/X _5192_/Q VPWR VGND sg13g2_dlygate4sd3_1
XFILLER_29_100 VPWR VGND sg13g2_fill_2
XFILLER_45_604 VPWR VGND sg13g2_decap_8
XFILLER_57_453 VPWR VGND sg13g2_fill_1
XFILLER_44_103 VPWR VGND sg13g2_decap_4
XFILLER_72_412 VPWR VGND sg13g2_fill_2
XFILLER_72_401 VPWR VGND sg13g2_decap_8
XFILLER_55_89 VPWR VGND sg13g2_fill_2
XFILLER_25_394 VPWR VGND sg13g2_decap_8
XFILLER_9_516 VPWR VGND sg13g2_decap_8
XFILLER_4_210 VPWR VGND sg13g2_decap_8
XFILLER_48_420 VPWR VGND sg13g2_decap_4
XFILLER_0_493 VPWR VGND sg13g2_decap_8
XFILLER_35_103 VPWR VGND sg13g2_decap_8
XFILLER_75_250 VPWR VGND sg13g2_decap_8
XFILLER_63_412 VPWR VGND sg13g2_fill_1
XFILLER_50_106 VPWR VGND sg13g2_decap_4
X_3950_ _3950_/Y _2615_/Y _3858_/A _3064_/A VPWR VGND sg13g2_a21oi_1
XFILLER_16_361 VPWR VGND sg13g2_decap_8
X_2901_ _2901_/Y _2901_/A _2941_/B VPWR VGND sg13g2_nor2_1
XFILLER_31_331 VPWR VGND sg13g2_decap_8
X_3881_ _3884_/A _3879_/Y _3880_/Y _3635_/Y VPWR VGND sg13g2_o21ai_1
X_2832_ _3026_/B _4652_/A _5439_/A _3403_/S VPWR VGND sg13g2_mux2_1
XFILLER_31_397 VPWR VGND sg13g2_fill_2
X_2763_ _3724_/A _3081_/B _3073_/A VPWR VGND sg13g2_nor2_1
X_4502_ _5192_/D hold774/X _3840_/Y _4509_/S VPWR VGND sg13g2_mux2_1
X_2694_ _2694_/X _2704_/C _2694_/B _2704_/B VPWR VGND sg13g2_and3_1
X_4433_ _4444_/B _4433_/A _4433_/B VPWR VGND sg13g2_nor2_1
Xfanout506 _2880_/B1 _3398_/B1 VPWR VGND sg13g2_buf_2
X_4364_ _5291_/D _3860_/Y hold821/X _4371_/S VPWR VGND sg13g2_mux2_1
Xfanout517 _3547_/A2 _2694_/X VPWR VGND sg13g2_buf_1
Xfanout528 _5129_/A fanout533/X VPWR VGND sg13g2_buf_1
Xfanout539 _5156_/A _5092_/A VPWR VGND sg13g2_buf_1
X_4295_ _5348_/D _4249_/A hold670/X _4299_/S VPWR VGND sg13g2_mux2_1
X_3315_ _4469_/B _3314_/Y _3315_/B _3315_/C VPWR VGND sg13g2_nand3b_1
XFILLER_39_420 VPWR VGND sg13g2_decap_4
X_3246_ _4353_/A _2585_/Y _3246_/A2 _3244_/X _3245_/Y VPWR VGND sg13g2_a22oi_1
XFILLER_39_453 VPWR VGND sg13g2_fill_2
XFILLER_27_615 VPWR VGND sg13g2_decap_4
X_3177_ _3177_/X _4194_/A1 _3175_/A _3176_/Y VPWR VGND sg13g2_a21o_1
XFILLER_26_114 VPWR VGND sg13g2_fill_2
XFILLER_26_125 VPWR VGND sg13g2_decap_8
XFILLER_54_434 VPWR VGND sg13g2_decap_8
XFILLER_26_158 VPWR VGND sg13g2_decap_8
XFILLER_54_467 VPWR VGND sg13g2_decap_8
XFILLER_25_37 VPWR VGND sg13g2_decap_8
XFILLER_41_106 VPWR VGND sg13g2_decap_4
XFILLER_50_640 VPWR VGND sg13g2_decap_8
XFILLER_50_651 VPWR VGND sg13g2_fill_1
XFILLER_10_515 VPWR VGND sg13g2_decap_8
XFILLER_10_548 VPWR VGND sg13g2_decap_8
XFILLER_6_519 VPWR VGND sg13g2_decap_8
XFILLER_77_537 VPWR VGND sg13g2_decap_8
XFILLER_66_11 VPWR VGND sg13g2_fill_2
XFILLER_66_44 VPWR VGND sg13g2_decap_8
XFILLER_18_615 VPWR VGND sg13g2_decap_4
XFILLER_17_158 VPWR VGND sg13g2_decap_8
XFILLER_45_467 VPWR VGND sg13g2_decap_8
XFILLER_72_297 VPWR VGND sg13g2_fill_2
XFILLER_72_286 VPWR VGND sg13g2_decap_8
XFILLER_60_459 VPWR VGND sg13g2_decap_8
XFILLER_15_92 VPWR VGND sg13g2_fill_1
XFILLER_9_324 VPWR VGND sg13g2_fill_1
XFILLER_5_541 VPWR VGND sg13g2_decap_8
Xoutput109 dmem_addr[1] _4526_/X VPWR VGND sg13g2_buf_1
XFILLER_5_574 VPWR VGND sg13g2_decap_8
XFILLER_56_7 VPWR VGND sg13g2_decap_8
X_3100_ _3109_/B _4207_/A _3100_/B VPWR VGND sg13g2_or2_1
X_4080_ _4081_/C _3714_/A _4078_/X _4079_/Y VPWR VGND sg13g2_a21oi_1
X_3031_ _3032_/B _2850_/B _4439_/B VPWR VGND sg13g2_nand2b_1
XFILLER_36_445 VPWR VGND sg13g2_decap_8
XFILLER_24_618 VPWR VGND sg13g2_decap_8
X_4982_ _4982_/Y _5142_/A VPWR VGND sg13g2_inv_1
X_3933_ _5416_/D _2539_/Y _4224_/B _3932_/Y VPWR VGND sg13g2_o21ai_1
X_3864_ _3866_/B _3893_/A _3893_/C _3893_/B VPWR VGND sg13g2_o21ai_1
X_2815_ _3201_/A _3210_/B _3210_/C VPWR VGND sg13g2_xnor2_1
X_3795_ _3795_/Y input89/X _3838_/B _3065_/Y VPWR VGND sg13g2_a21oi_1
X_2746_ _2749_/B _5433_/Q _2870_/B _3004_/B1 _5401_/Q VPWR VGND sg13g2_a22oi_1
X_5465_ _5465_/X _5465_/A VPWR VGND sg13g2_buf_1
X_2677_ _2960_/A _2677_/A _2676_/Y VPWR VGND sg13g2_nor2b_1
X_4416_ _5242_/D _3093_/Y hold701/X _4427_/B VPWR VGND sg13g2_mux2_1
X_5396_ _5396_/Q _5435_/CLK _5396_/D _5136_/Y VPWR VGND sg13g2_dfrbpq_1
Xfanout303 _3879_/B _4446_/C VPWR VGND sg13g2_buf_1
Xfanout314 _3936_/B _3442_/X VPWR VGND sg13g2_buf_1
Xfanout325 _4219_/A2 _3154_/B1 VPWR VGND sg13g2_buf_1
Xfanout336 _3313_/A _2974_/C VPWR VGND sg13g2_buf_1
Xfanout347 _4580_/B _4572_/Y VPWR VGND sg13g2_buf_1
X_4347_ _5303_/D _2941_/A _4350_/S _4346_/Y VPWR VGND sg13g2_a21oi_1
Xfanout358 _4160_/A _4158_/A VPWR VGND sg13g2_buf_1
Xfanout369 _3144_/A _3148_/A VPWR VGND sg13g2_buf_1
X_4278_ _4278_/Y _4278_/A _4280_/B VPWR VGND sg13g2_nand2_1
XFILLER_46_209 VPWR VGND sg13g2_decap_8
X_3229_ _3231_/B _3253_/A _3232_/C _4441_/A VPWR VGND sg13g2_o21ai_1
XFILLER_10_389 VPWR VGND sg13g2_fill_2
XFILLER_77_65 VPWR VGND sg13g2_decap_8
XFILLER_65_529 VPWR VGND sg13g2_decap_8
XFILLER_58_581 VPWR VGND sg13g2_decap_8
XFILLER_45_253 VPWR VGND sg13g2_decap_4
XFILLER_33_437 VPWR VGND sg13g2_decap_8
XFILLER_60_245 VPWR VGND sg13g2_decap_8
XFILLER_14_651 VPWR VGND sg13g2_fill_1
XFILLER_41_470 VPWR VGND sg13g2_fill_1
XFILLER_9_121 VPWR VGND sg13g2_decap_8
X_3580_ _3580_/Y _3580_/A _3580_/B VPWR VGND sg13g2_nand2_1
X_2600_ _2600_/Y input8/X VPWR VGND sg13g2_inv_1
X_5250_ _5250_/Q clkload7/A _5250_/D _4990_/Y VPWR VGND sg13g2_dfrbpq_1
XFILLER_54_4 VPWR VGND sg13g2_decap_4
X_4201_ _4203_/B _4201_/A _4201_/B _4201_/C VPWR VGND sg13g2_nand3_1
X_5181_ _5181_/Q clkload9/A _5181_/D _4921_/Y VPWR VGND sg13g2_dfrbpq_1
XFILLER_68_301 VPWR VGND sg13g2_decap_8
X_4132_ _4133_/C _4132_/A _4132_/B _4132_/C VPWR VGND sg13g2_or3_1
X_4063_ _4063_/Y _3714_/A _4062_/X _4171_/B1 VPWR VGND sg13g2_o21ai_1
XFILLER_68_378 VPWR VGND sg13g2_fill_2
X_3014_ _3015_/C _4441_/C _4211_/A2 _3011_/Y VPWR VGND sg13g2_a21oi_1
XFILLER_64_595 VPWR VGND sg13g2_decap_8
X_4965_ _4965_/Y _5076_/A VPWR VGND sg13g2_inv_1
XFILLER_51_256 VPWR VGND sg13g2_decap_8
X_3916_ _3919_/B _4020_/A _3916_/B VPWR VGND sg13g2_nor2_1
XFILLER_20_643 VPWR VGND sg13g2_fill_1
X_4896_ _4905_/B _4904_/A _4896_/B VPWR VGND sg13g2_xnor2_1
X_3847_ _3847_/Y _3847_/A _3847_/B VPWR VGND sg13g2_nand2_1
X_3778_ _3878_/B _4445_/A _3879_/B _4445_/B _3920_/B VPWR VGND sg13g2_nor4_1
X_2729_ _4201_/A _3011_/A _2730_/B VPWR VGND sg13g2_nand2_1
X_5448_ _5448_/X _5448_/A VPWR VGND sg13g2_buf_1
X_5379_ _5379_/Q _5414_/CLK _5379_/D _5119_/Y VPWR VGND sg13g2_dfrbpq_1
XFILLER_59_378 VPWR VGND sg13g2_decap_8
XFILLER_74_359 VPWR VGND sg13g2_decap_8
XFILLER_15_415 VPWR VGND sg13g2_decap_8
XFILLER_27_275 VPWR VGND sg13g2_fill_1
XFILLER_55_584 VPWR VGND sg13g2_decap_8
XFILLER_42_256 VPWR VGND sg13g2_decap_8
XFILLER_63_78 VPWR VGND sg13g2_decap_8
XFILLER_11_621 VPWR VGND sg13g2_decap_8
XFILLER_23_470 VPWR VGND sg13g2_decap_4
XFILLER_23_492 VPWR VGND sg13g2_decap_4
XFILLER_70_598 VPWR VGND sg13g2_decap_8
XFILLER_6_113 VPWR VGND sg13g2_decap_8
XFILLER_2_330 VPWR VGND sg13g2_decap_8
XFILLER_2_396 VPWR VGND sg13g2_fill_1
XFILLER_65_304 VPWR VGND sg13g2_decap_8
XFILLER_65_348 VPWR VGND sg13g2_fill_2
XFILLER_46_540 VPWR VGND sg13g2_decap_4
XFILLER_18_286 VPWR VGND sg13g2_fill_2
XFILLER_46_595 VPWR VGND sg13g2_decap_8
XFILLER_18_297 VPWR VGND sg13g2_decap_8
XFILLER_61_532 VPWR VGND sg13g2_decap_8
XFILLER_21_407 VPWR VGND sg13g2_decap_8
XFILLER_33_267 VPWR VGND sg13g2_fill_2
X_4750_ _4750_/Y _4756_/A VPWR VGND sg13g2_inv_1
XFILLER_61_598 VPWR VGND sg13g2_decap_4
X_4681_ _4682_/B _4681_/A _4681_/B VPWR VGND sg13g2_xnor2_1
X_3701_ _3820_/B _3701_/A _3763_/B VPWR VGND sg13g2_nor2b_1
X_3632_ _4629_/C _5258_/Q _2754_/B _3631_/Y VPWR VGND sg13g2_o21ai_1
X_5302_ _5302_/Q _5430_/CLK _5302_/D _5042_/Y VPWR VGND sg13g2_dfrbpq_1
X_3563_ _3731_/B _4110_/B _3563_/B VPWR VGND sg13g2_nand2_1
XFILLER_45_0 VPWR VGND sg13g2_decap_8
X_3494_ _3496_/A _3494_/A _3494_/B _3494_/C _3494_/D VPWR VGND sg13g2_and4_1
X_5233_ _5233_/Q _5434_/CLK _5233_/D _4973_/Y VPWR VGND sg13g2_dfrbpq_1
X_5164_ _5164_/Y _5164_/A VPWR VGND sg13g2_inv_1
XFILLER_69_643 VPWR VGND sg13g2_decap_4
X_4115_ _4115_/Y _4448_/D _4115_/B VPWR VGND sg13g2_xnor2_1
XFILLER_56_304 VPWR VGND sg13g2_decap_4
X_5095_ _5095_/Y _5095_/A VPWR VGND sg13g2_inv_1
XFILLER_17_38 VPWR VGND sg13g2_fill_1
X_4046_ _4046_/Y _4095_/A _3574_/A _3507_/A _4459_/A1 VPWR VGND sg13g2_a22oi_1
XFILLER_71_307 VPWR VGND sg13g2_fill_1
XFILLER_52_532 VPWR VGND sg13g2_fill_1
XFILLER_12_418 VPWR VGND sg13g2_fill_1
XFILLER_33_59 VPWR VGND sg13g2_fill_2
X_4948_ _4948_/Y _4954_/A VPWR VGND sg13g2_inv_1
XFILLER_20_451 VPWR VGND sg13g2_decap_8
X_4879_ _4885_/B _4879_/A _4879_/B VPWR VGND sg13g2_xnor2_1
XFILLER_4_617 VPWR VGND sg13g2_decap_8
XFILLER_47_304 VPWR VGND sg13g2_decap_8
XFILLER_28_551 VPWR VGND sg13g2_decap_8
XFILLER_47_348 VPWR VGND sg13g2_decap_8
XFILLER_28_562 VPWR VGND sg13g2_fill_2
XFILLER_74_44 VPWR VGND sg13g2_decap_8
XFILLER_74_178 VPWR VGND sg13g2_decap_8
XFILLER_43_587 VPWR VGND sg13g2_decap_8
XFILLER_70_362 VPWR VGND sg13g2_decap_4
XFILLER_30_215 VPWR VGND sg13g2_decap_4
XFILLER_11_440 VPWR VGND sg13g2_decap_8
XFILLER_30_248 VPWR VGND sg13g2_decap_8
XFILLER_7_400 VPWR VGND sg13g2_decap_8
XFILLER_7_444 VPWR VGND sg13g2_fill_1
XFILLER_78_451 VPWR VGND sg13g2_decap_8
XFILLER_78_440 VPWR VGND sg13g2_decap_4
XFILLER_38_315 VPWR VGND sg13g2_fill_1
XFILLER_38_326 VPWR VGND sg13g2_decap_8
XFILLER_21_204 VPWR VGND sg13g2_decap_8
XFILLER_21_215 VPWR VGND sg13g2_fill_2
X_4802_ _4808_/D _4807_/A _4802_/B VPWR VGND sg13g2_xnor2_1
X_2994_ _3750_/B _4439_/A _4439_/C _4436_/C _2994_/D VPWR VGND sg13g2_nor4_2
XFILLER_21_248 VPWR VGND sg13g2_fill_1
X_4733_ _4740_/B _4734_/A _4746_/D VPWR VGND sg13g2_nand2_1
XFILLER_9_61 VPWR VGND sg13g2_decap_8
X_4664_ _4664_/Y _4664_/A _4664_/B VPWR VGND sg13g2_nand2_1
X_4595_ _4595_/Y _4360_/A _4621_/A _5454_/A _4618_/B2 VPWR VGND sg13g2_a22oi_1
X_3615_ _3615_/X _3938_/B _3659_/B VPWR VGND sg13g2_and2_1
X_3546_ _3549_/A _5343_/Q _3546_/A2 _3583_/B1 _5279_/Q VPWR VGND sg13g2_a22oi_1
XFILLER_0_119 VPWR VGND sg13g2_decap_8
X_5216_ _5216_/Q _5216_/CLK _5216_/D _4956_/Y VPWR VGND sg13g2_dfrbpq_1
X_3477_ _3477_/Y _3477_/A _3477_/B _3477_/C _3477_/D VPWR VGND sg13g2_nand4_1
XFILLER_69_451 VPWR VGND sg13g2_fill_2
X_5147_ _5147_/Y _5147_/A VPWR VGND sg13g2_inv_1
XFILLER_57_624 VPWR VGND sg13g2_decap_8
X_5078_ _5078_/Y _5174_/A VPWR VGND sg13g2_inv_1
XFILLER_56_134 VPWR VGND sg13g2_decap_4
X_4029_ _4030_/B _4029_/A _4041_/B VPWR VGND sg13g2_nand2_1
XFILLER_56_189 VPWR VGND sg13g2_decap_4
XFILLER_37_370 VPWR VGND sg13g2_decap_8
XFILLER_37_381 VPWR VGND sg13g2_fill_1
XFILLER_72_649 VPWR VGND sg13g2_fill_2
XFILLER_71_148 VPWR VGND sg13g2_fill_2
XFILLER_71_137 VPWR VGND sg13g2_fill_2
XFILLER_71_126 VPWR VGND sg13g2_fill_1
XFILLER_25_565 VPWR VGND sg13g2_fill_2
XFILLER_44_36 VPWR VGND sg13g2_fill_2
XFILLER_44_58 VPWR VGND sg13g2_decap_8
XFILLER_52_351 VPWR VGND sg13g2_decap_8
XFILLER_12_226 VPWR VGND sg13g2_decap_8
XFILLER_40_535 VPWR VGND sg13g2_decap_8
XFILLER_4_414 VPWR VGND sg13g2_decap_8
XFILLER_79_215 VPWR VGND sg13g2_fill_2
XFILLER_69_44 VPWR VGND sg13g2_fill_2
XFILLER_79_248 VPWR VGND sg13g2_fill_2
XFILLER_79_237 VPWR VGND sg13g2_fill_2
XFILLER_0_642 VPWR VGND sg13g2_decap_8
XFILLER_48_602 VPWR VGND sg13g2_decap_8
XFILLER_47_123 VPWR VGND sg13g2_decap_8
XFILLER_18_92 VPWR VGND sg13g2_fill_1
XFILLER_28_370 VPWR VGND sg13g2_fill_2
XFILLER_16_598 VPWR VGND sg13g2_decap_8
XFILLER_43_395 VPWR VGND sg13g2_decap_8
XFILLER_34_80 VPWR VGND sg13g2_decap_8
XFILLER_7_263 VPWR VGND sg13g2_decap_8
X_4380_ _4380_/Y _4380_/A _4388_/S VPWR VGND sg13g2_nand2_1
X_3400_ _3400_/Y _5276_/Q _3400_/A2 _3400_/B1 _5340_/Q _3398_/Y VPWR VGND sg13g2_a221oi_1
X_3331_ _3332_/D _5294_/Q _3674_/B1 _3676_/B1 _5358_/Q VPWR VGND sg13g2_a22oi_1
X_3262_ _4470_/A _3262_/A _3262_/B _3262_/C _3262_/D VPWR VGND sg13g2_nand4_1
X_5001_ _5001_/Y _5001_/A VPWR VGND sg13g2_inv_1
X_3193_ _3193_/Y _3193_/A _3193_/B _3193_/C VPWR VGND sg13g2_nand3_1
XFILLER_78_281 VPWR VGND sg13g2_fill_1
XFILLER_78_270 VPWR VGND sg13g2_decap_8
XFILLER_66_443 VPWR VGND sg13g2_decap_8
XFILLER_26_307 VPWR VGND sg13g2_decap_4
XFILLER_53_104 VPWR VGND sg13g2_fill_1
XFILLER_34_340 VPWR VGND sg13g2_decap_8
XFILLER_22_524 VPWR VGND sg13g2_decap_8
XFILLER_22_546 VPWR VGND sg13g2_decap_4
X_2977_ _3148_/B _3191_/A _3166_/A _3206_/B VPWR VGND sg13g2_nand3_1
X_4716_ _4716_/X _4728_/A _4716_/B VPWR VGND sg13g2_xor2_1
X_4647_ _4647_/Y _4664_/A _4647_/B VPWR VGND sg13g2_nand2_1
Xhold720 hold720/X _5316_/Q VPWR VGND sg13g2_dlygate4sd3_1
Xhold731 hold731/X _5179_/Q VPWR VGND sg13g2_dlygate4sd3_1
Xhold742 hold742/X _5189_/Q VPWR VGND sg13g2_dlygate4sd3_1
Xhold753 hold753/X _5379_/Q VPWR VGND sg13g2_dlygate4sd3_1
Xhold764 hold764/X _5331_/Q VPWR VGND sg13g2_dlygate4sd3_1
X_4578_ _4579_/B _4749_/A _4559_/B _5450_/A _4580_/B VPWR VGND sg13g2_a22oi_1
Xhold797 hold797/X _5406_/Q VPWR VGND sg13g2_dlygate4sd3_1
Xhold786 hold786/X _5404_/Q VPWR VGND sg13g2_dlygate4sd3_1
Xhold775 hold775/X _5193_/Q VPWR VGND sg13g2_dlygate4sd3_1
X_3529_ _3531_/D _5312_/Q _3548_/A2 _3546_/A2 _5344_/Q VPWR VGND sg13g2_a22oi_1
XFILLER_39_25 VPWR VGND sg13g2_fill_2
XFILLER_39_36 VPWR VGND sg13g2_fill_2
XFILLER_29_167 VPWR VGND sg13g2_fill_1
XFILLER_57_487 VPWR VGND sg13g2_fill_2
XFILLER_44_159 VPWR VGND sg13g2_decap_4
XFILLER_52_170 VPWR VGND sg13g2_decap_4
XFILLER_40_332 VPWR VGND sg13g2_decap_8
XFILLER_71_34 VPWR VGND sg13g2_fill_2
XFILLER_40_354 VPWR VGND sg13g2_fill_1
XFILLER_71_67 VPWR VGND sg13g2_fill_2
XFILLER_40_398 VPWR VGND sg13g2_fill_1
XFILLER_4_288 VPWR VGND sg13g2_decap_8
XFILLER_48_487 VPWR VGND sg13g2_decap_4
XFILLER_75_295 VPWR VGND sg13g2_fill_2
XFILLER_16_351 VPWR VGND sg13g2_fill_1
XFILLER_35_148 VPWR VGND sg13g2_fill_1
X_2900_ _3025_/A _3233_/A VPWR VGND sg13g2_inv_1
XFILLER_16_395 VPWR VGND sg13g2_decap_8
X_3880_ _3880_/Y _4457_/B _3879_/B _4045_/A VPWR VGND sg13g2_o21ai_1
X_2831_ _4530_/A _2829_/Y _2827_/Y _2830_/Y VPWR VGND sg13g2_a21oi_2
X_2762_ _3073_/A _3101_/A _3018_/A VPWR VGND sg13g2_xnor2_1
X_4501_ _5193_/D hold775/X _3815_/Y _4509_/S VPWR VGND sg13g2_mux2_1
X_4432_ _4432_/Y _3340_/Y _3746_/B _4463_/B VPWR VGND sg13g2_a21oi_1
X_2693_ _2698_/B _2704_/C _2895_/C VPWR VGND sg13g2_nand2_1
X_4363_ _5292_/D _3840_/Y hold732/X _4371_/S VPWR VGND sg13g2_mux2_1
Xfanout507 _3372_/B1 _3398_/B1 VPWR VGND sg13g2_buf_1
Xfanout518 _3365_/B1 _3671_/B1 VPWR VGND sg13g2_buf_1
Xfanout529 _5095_/A _5158_/A VPWR VGND sg13g2_buf_1
X_4294_ _5349_/D _4012_/Y hold817/X _4294_/S VPWR VGND sg13g2_mux2_1
X_3314_ _3314_/Y _4045_/A _3289_/B _3056_/A _2965_/C _3313_/Y VPWR VGND sg13g2_a221oi_1
X_3245_ _3245_/Y _2576_/A _4195_/A2 _3246_/A2 VPWR VGND sg13g2_a21oi_1
X_3176_ _3176_/Y input94/X _4194_/A1 _3065_/B VPWR VGND sg13g2_o21ai_1
XFILLER_66_262 VPWR VGND sg13g2_decap_8
XFILLER_81_210 VPWR VGND sg13g2_decap_8
XFILLER_66_273 VPWR VGND sg13g2_fill_2
XFILLER_41_129 VPWR VGND sg13g2_decap_8
XFILLER_22_398 VPWR VGND sg13g2_decap_8
XFILLER_66_23 VPWR VGND sg13g2_decap_4
XFILLER_45_424 VPWR VGND sg13g2_decap_8
XFILLER_33_608 VPWR VGND sg13g2_decap_8
XFILLER_72_265 VPWR VGND sg13g2_decap_8
XFILLER_60_438 VPWR VGND sg13g2_decap_8
XFILLER_13_365 VPWR VGND sg13g2_decap_8
XFILLER_9_369 VPWR VGND sg13g2_decap_8
XFILLER_49_7 VPWR VGND sg13g2_decap_8
XFILLER_68_527 VPWR VGND sg13g2_decap_8
XFILLER_36_402 VPWR VGND sg13g2_decap_8
X_3030_ _3269_/A _3268_/B _3268_/C _3270_/A VPWR VGND sg13g2_o21ai_1
XFILLER_63_210 VPWR VGND sg13g2_fill_1
XFILLER_36_479 VPWR VGND sg13g2_fill_1
X_4981_ _4981_/Y _5134_/A VPWR VGND sg13g2_inv_1
XFILLER_51_449 VPWR VGND sg13g2_decap_8
X_3932_ _3932_/Y _4179_/S _3932_/B VPWR VGND sg13g2_nand2_1
X_3863_ _3863_/Y _3893_/B _3862_/Y _3656_/B VPWR VGND sg13g2_o21ai_1
X_2814_ _2915_/C _3210_/B _3210_/C VPWR VGND sg13g2_nor2_1
X_3794_ _3794_/X _3838_/B _4480_/A VPWR VGND sg13g2_or2_1
XFILLER_75_0 VPWR VGND sg13g2_decap_8
X_2745_ _2749_/A _5241_/Q _2938_/B VPWR VGND sg13g2_nand2_1
XFILLER_8_380 VPWR VGND sg13g2_decap_8
X_5464_ _5464_/X _5464_/A VPWR VGND sg13g2_buf_1
X_2676_ _2676_/Y _2999_/A _4520_/B _2999_/B VPWR VGND sg13g2_a21oi_1
X_5395_ _5395_/Q _5427_/CLK _5395_/D _5135_/Y VPWR VGND sg13g2_dfrbpq_1
X_4415_ _5243_/D _3068_/Y _4424_/S _4414_/Y VPWR VGND sg13g2_o21ai_1
Xfanout304 _3920_/A _3587_/Y VPWR VGND sg13g2_buf_1
X_4346_ _4346_/Y _4346_/A _4350_/S VPWR VGND sg13g2_nor2_1
Xfanout315 _4448_/B _3442_/X VPWR VGND sg13g2_buf_1
Xfanout326 _3154_/B1 _3063_/Y VPWR VGND sg13g2_buf_1
Xfanout337 _2974_/C _2876_/Y VPWR VGND sg13g2_buf_1
Xfanout348 _3763_/B _3686_/Y VPWR VGND sg13g2_buf_1
Xfanout359 _4158_/A _4439_/D VPWR VGND sg13g2_buf_1
X_4277_ _5362_/D _2819_/A _4276_/B _4276_/Y VPWR VGND sg13g2_o21ai_1
XFILLER_59_549 VPWR VGND sg13g2_decap_8
X_3228_ _3242_/B _3228_/A _3228_/B VPWR VGND sg13g2_nor2_1
XFILLER_67_560 VPWR VGND sg13g2_fill_1
X_3159_ _3182_/B _3204_/A _3226_/A _2914_/Y VPWR VGND sg13g2_a21oi_1
XFILLER_10_335 VPWR VGND sg13g2_decap_8
XFILLER_22_184 VPWR VGND sg13g2_decap_8
XFILLER_2_545 VPWR VGND sg13g2_fill_1
XFILLER_77_44 VPWR VGND sg13g2_decap_8
XFILLER_18_457 VPWR VGND sg13g2_fill_1
XFILLER_73_563 VPWR VGND sg13g2_fill_1
XFILLER_73_552 VPWR VGND sg13g2_decap_8
XFILLER_45_276 VPWR VGND sg13g2_decap_8
XFILLER_45_287 VPWR VGND sg13g2_fill_2
XFILLER_73_585 VPWR VGND sg13g2_decap_8
XFILLER_60_224 VPWR VGND sg13g2_decap_8
XFILLER_9_100 VPWR VGND sg13g2_decap_8
XFILLER_42_91 VPWR VGND sg13g2_decap_8
XFILLER_5_383 VPWR VGND sg13g2_decap_8
X_4200_ _4215_/A _4208_/B _4198_/Y _4199_/Y VPWR VGND sg13g2_o21ai_1
XFILLER_3_30 VPWR VGND sg13g2_fill_1
X_5180_ _5180_/Q _5414_/CLK _5180_/D _4920_/Y VPWR VGND sg13g2_dfrbpq_1
X_4131_ _4131_/Y _4131_/A _4131_/B _4131_/C VPWR VGND sg13g2_nor3_1
XFILLER_49_560 VPWR VGND sg13g2_decap_8
X_4062_ _4062_/X _4062_/A _4088_/C VPWR VGND sg13g2_and2_1
XFILLER_68_357 VPWR VGND sg13g2_decap_8
XFILLER_56_519 VPWR VGND sg13g2_decap_8
X_3013_ _3015_/B _3011_/A _4209_/A1 _4441_/D _3236_/B1 _3012_/Y VPWR VGND sg13g2_a221oi_1
XFILLER_76_390 VPWR VGND sg13g2_decap_8
XFILLER_64_574 VPWR VGND sg13g2_decap_8
XFILLER_51_235 VPWR VGND sg13g2_decap_8
X_4964_ _4964_/Y _4964_/A VPWR VGND sg13g2_inv_1
Xclkbuf_leaf_16_clk _5224_/CLK clkbuf_leaf_3_clk/A VPWR VGND sg13g2_buf_8
X_3915_ _3919_/A _3879_/A _3600_/A _3914_/Y VPWR VGND sg13g2_o21ai_1
X_4895_ _4895_/Y _4914_/A _4896_/B VPWR VGND sg13g2_nor2b_1
X_3846_ _3846_/Y _3879_/A _3697_/A _3845_/Y VPWR VGND sg13g2_o21ai_1
X_3777_ _3902_/B _4445_/A _3920_/B VPWR VGND sg13g2_nor2_1
X_2728_ _2730_/B _4736_/A _5448_/A _3392_/S VPWR VGND sg13g2_mux2_1
X_5447_ _5447_/X _5447_/A VPWR VGND sg13g2_buf_1
X_2659_ _2660_/B _2999_/A _2659_/B VPWR VGND sg13g2_nor2_1
X_5378_ _5378_/Q clkload6/A _5378_/D _5118_/Y VPWR VGND sg13g2_dfrbpq_1
X_4329_ _5317_/D _4012_/Y hold737/X _4329_/S VPWR VGND sg13g2_mux2_1
XFILLER_59_357 VPWR VGND sg13g2_decap_8
XFILLER_47_47 VPWR VGND sg13g2_decap_8
XFILLER_47_58 VPWR VGND sg13g2_fill_1
XFILLER_74_338 VPWR VGND sg13g2_decap_8
XFILLER_27_221 VPWR VGND sg13g2_decap_8
XFILLER_55_552 VPWR VGND sg13g2_decap_8
XFILLER_27_254 VPWR VGND sg13g2_decap_8
XFILLER_27_298 VPWR VGND sg13g2_decap_8
XFILLER_42_224 VPWR VGND sg13g2_decap_8
XFILLER_70_522 VPWR VGND sg13g2_fill_1
XFILLER_30_419 VPWR VGND sg13g2_decap_8
XFILLER_10_132 VPWR VGND sg13g2_fill_1
XFILLER_10_165 VPWR VGND sg13g2_fill_2
XFILLER_7_648 VPWR VGND sg13g2_decap_4
XFILLER_5_0 VPWR VGND sg13g2_decap_8
XFILLER_78_600 VPWR VGND sg13g2_decap_8
XFILLER_77_143 VPWR VGND sg13g2_fill_2
XFILLER_77_176 VPWR VGND sg13g2_decap_4
XFILLER_18_243 VPWR VGND sg13g2_fill_2
XFILLER_18_254 VPWR VGND sg13g2_fill_2
XFILLER_37_91 VPWR VGND sg13g2_fill_1
XFILLER_61_511 VPWR VGND sg13g2_decap_8
XFILLER_61_577 VPWR VGND sg13g2_decap_8
X_3700_ _3700_/Y _3704_/A _4445_/C _5465_/A VPWR VGND sg13g2_nor3_1
XFILLER_41_290 VPWR VGND sg13g2_decap_8
X_4680_ _4681_/B _4672_/A _4672_/B _4669_/Y VPWR VGND sg13g2_o21ai_1
X_3631_ _3631_/Y _3631_/A _3631_/B _3631_/C _3631_/D VPWR VGND sg13g2_nand4_1
X_3562_ _4132_/A _4110_/B _3563_/B VPWR VGND sg13g2_and2_1
X_5301_ _5301_/Q _5425_/CLK _5301_/D _5041_/Y VPWR VGND sg13g2_dfrbpq_1
X_3493_ _3494_/D _5314_/Q _3683_/A2 _3508_/B _5410_/Q VPWR VGND sg13g2_a22oi_1
XFILLER_5_191 VPWR VGND sg13g2_fill_1
X_5232_ _5232_/Q _5392_/CLK _5232_/D _4972_/Y VPWR VGND sg13g2_dfrbpq_1
Xclkbuf_leaf_5_clk _5427_/CLK clkbuf_leaf_9_clk/A VPWR VGND sg13g2_buf_8
X_5163_ _5163_/Y _5164_/A VPWR VGND sg13g2_inv_1
X_4114_ _4114_/Y _4114_/A _4114_/B VPWR VGND sg13g2_xnor2_1
XFILLER_68_154 VPWR VGND sg13g2_decap_8
X_5094_ _5094_/Y _5095_/A VPWR VGND sg13g2_inv_1
XFILLER_37_552 VPWR VGND sg13g2_decap_8
X_4045_ _4051_/A _4045_/A _4045_/B VPWR VGND sg13g2_nor2_1
XFILLER_56_349 VPWR VGND sg13g2_decap_8
XFILLER_37_585 VPWR VGND sg13g2_decap_8
XFILLER_52_511 VPWR VGND sg13g2_decap_8
XFILLER_64_371 VPWR VGND sg13g2_decap_8
XFILLER_24_213 VPWR VGND sg13g2_decap_4
X_4947_ _4947_/Y _4951_/A VPWR VGND sg13g2_inv_1
XFILLER_52_588 VPWR VGND sg13g2_decap_8
X_4878_ _4878_/Y _4878_/A _4879_/B VPWR VGND sg13g2_nor2_1
X_3829_ _3836_/B _4020_/A _3829_/B VPWR VGND sg13g2_nor2_1
XFILLER_58_46 VPWR VGND sg13g2_decap_8
XFILLER_59_154 VPWR VGND sg13g2_fill_1
XFILLER_59_143 VPWR VGND sg13g2_decap_8
XFILLER_47_327 VPWR VGND sg13g2_decap_8
XFILLER_74_113 VPWR VGND sg13g2_decap_4
XFILLER_59_187 VPWR VGND sg13g2_fill_1
XFILLER_74_157 VPWR VGND sg13g2_decap_8
XFILLER_43_566 VPWR VGND sg13g2_decap_8
XFILLER_70_341 VPWR VGND sg13g2_decap_8
XFILLER_15_279 VPWR VGND sg13g2_decap_8
XFILLER_11_485 VPWR VGND sg13g2_decap_8
XFILLER_65_135 VPWR VGND sg13g2_fill_2
XFILLER_0_53 VPWR VGND sg13g2_decap_8
XFILLER_80_105 VPWR VGND sg13g2_decap_8
XFILLER_34_522 VPWR VGND sg13g2_decap_4
XFILLER_61_363 VPWR VGND sg13g2_decap_4
X_4801_ _4803_/A _4840_/A _4791_/B _4794_/Y VPWR VGND sg13g2_a21oi_1
X_2993_ _3099_/B _2993_/A _3144_/A _3140_/B VPWR VGND sg13g2_nor3_1
X_4732_ _4737_/A _4698_/B _4730_/Y _4731_/Y _4723_/Y _4729_/Y VPWR VGND sg13g2_a221oi_1
X_4663_ _4664_/B _4663_/A _4663_/B VPWR VGND sg13g2_xnor2_1
X_3614_ _3659_/B _2895_/B _5460_/A _3634_/A VPWR VGND sg13g2_mux2_1
X_4594_ _4594_/Y _5454_/A _4594_/B VPWR VGND sg13g2_xnor2_1
X_3545_ _4112_/A _3714_/C _3715_/A VPWR VGND sg13g2_nand2_1
X_3476_ _3477_/D _5412_/Q _3508_/B _3684_/B1 _5284_/Q VPWR VGND sg13g2_a22oi_1
X_5215_ _5215_/Q _5216_/CLK _5215_/D _4955_/Y VPWR VGND sg13g2_dfrbpq_1
XFILLER_69_463 VPWR VGND sg13g2_decap_4
X_5146_ _5146_/Y _5148_/A VPWR VGND sg13g2_inv_1
X_5077_ _5077_/Y _5135_/A VPWR VGND sg13g2_inv_1
XFILLER_57_647 VPWR VGND sg13g2_fill_1
X_4028_ _4028_/Y _3120_/A _4018_/Y _4027_/Y _4043_/A _4026_/Y VPWR VGND sg13g2_a221oi_1
XFILLER_72_628 VPWR VGND sg13g2_decap_8
XFILLER_25_533 VPWR VGND sg13g2_decap_4
XFILLER_44_26 VPWR VGND sg13g2_fill_1
XFILLER_52_385 VPWR VGND sg13g2_fill_2
XFILLER_52_396 VPWR VGND sg13g2_fill_2
XFILLER_69_78 VPWR VGND sg13g2_decap_8
XFILLER_47_113 VPWR VGND sg13g2_fill_1
XFILLER_75_455 VPWR VGND sg13g2_decap_8
XFILLER_18_71 VPWR VGND sg13g2_decap_8
XFILLER_28_360 VPWR VGND sg13g2_fill_2
XFILLER_47_179 VPWR VGND sg13g2_decap_4
XFILLER_16_522 VPWR VGND sg13g2_decap_4
XFILLER_75_499 VPWR VGND sg13g2_decap_8
XFILLER_62_127 VPWR VGND sg13g2_fill_2
XFILLER_16_577 VPWR VGND sg13g2_decap_8
XFILLER_43_374 VPWR VGND sg13g2_decap_8
XFILLER_70_182 VPWR VGND sg13g2_decap_8
XFILLER_11_282 VPWR VGND sg13g2_decap_8
XFILLER_79_7 VPWR VGND sg13g2_decap_8
X_3330_ _3332_/C _5390_/Q _3676_/A2 _2714_/B VPWR VGND sg13g2_a21oi_1
X_5000_ _5000_/Y _5160_/A VPWR VGND sg13g2_inv_1
X_3261_ _3262_/D _3261_/A _3261_/B _3261_/C VPWR VGND sg13g2_nor3_1
XFILLER_39_625 VPWR VGND sg13g2_fill_1
X_3192_ _3193_/C _3239_/A _4100_/A _3192_/S VPWR VGND sg13g2_mux2_1
XFILLER_39_647 VPWR VGND sg13g2_fill_1
XFILLER_66_488 VPWR VGND sg13g2_decap_8
XFILLER_19_393 VPWR VGND sg13g2_decap_8
XFILLER_66_499 VPWR VGND sg13g2_fill_2
XFILLER_53_149 VPWR VGND sg13g2_decap_4
XFILLER_22_503 VPWR VGND sg13g2_decap_8
XFILLER_22_569 VPWR VGND sg13g2_decap_8
X_2976_ _3171_/B _3191_/A _3206_/B VPWR VGND sg13g2_nand2_1
XFILLER_30_591 VPWR VGND sg13g2_decap_8
X_4715_ _4725_/B _4728_/A _4716_/B VPWR VGND sg13g2_nand2b_1
X_4646_ _4647_/B _4646_/A _4646_/B VPWR VGND sg13g2_xor2_1
Xhold710 hold710/X _5427_/Q VPWR VGND sg13g2_dlygate4sd3_1
Xhold721 hold721/X _5327_/Q VPWR VGND sg13g2_dlygate4sd3_1
X_4577_ _4577_/Y _4581_/B _4576_/Y _4531_/A VPWR VGND sg13g2_a21oi_1
Xhold732 hold732/X _5292_/Q VPWR VGND sg13g2_dlygate4sd3_1
Xhold743 hold743/X _5391_/Q VPWR VGND sg13g2_dlygate4sd3_1
Xhold754 hold754/X _5364_/Q VPWR VGND sg13g2_dlygate4sd3_1
Xhold787 hold787/X _5185_/Q VPWR VGND sg13g2_dlygate4sd3_1
Xhold776 hold776/X _5267_/Q VPWR VGND sg13g2_dlygate4sd3_1
Xhold765 hold765/X _5420_/Q VPWR VGND sg13g2_dlygate4sd3_1
X_3528_ _3531_/C _5180_/Q _3547_/A2 _3684_/B1 _5280_/Q VPWR VGND sg13g2_a22oi_1
Xhold798 hold798/X _5321_/Q VPWR VGND sg13g2_dlygate4sd3_1
X_3459_ _3460_/D _5379_/Q _3492_/B _2817_/C VPWR VGND sg13g2_a21oi_1
X_5129_ _5129_/Y _5129_/A VPWR VGND sg13g2_inv_1
XFILLER_57_422 VPWR VGND sg13g2_decap_8
XFILLER_17_319 VPWR VGND sg13g2_decap_8
XFILLER_57_466 VPWR VGND sg13g2_decap_8
XFILLER_72_436 VPWR VGND sg13g2_decap_8
XFILLER_37_190 VPWR VGND sg13g2_decap_8
XFILLER_25_363 VPWR VGND sg13g2_decap_8
XFILLER_13_536 VPWR VGND sg13g2_decap_8
XFILLER_40_322 VPWR VGND sg13g2_fill_1
XFILLER_9_507 VPWR VGND sg13g2_decap_4
XFILLER_71_79 VPWR VGND sg13g2_fill_1
XFILLER_21_591 VPWR VGND sg13g2_fill_2
XFILLER_40_388 VPWR VGND sg13g2_decap_4
XFILLER_48_433 VPWR VGND sg13g2_fill_1
XFILLER_48_455 VPWR VGND sg13g2_decap_8
XFILLER_48_499 VPWR VGND sg13g2_decap_8
XFILLER_75_274 VPWR VGND sg13g2_decap_8
X_2830_ _2830_/Y _5234_/Q _2714_/A _2880_/B1 VPWR VGND sg13g2_a21oi_1
XFILLER_31_377 VPWR VGND sg13g2_fill_1
XFILLER_12_580 VPWR VGND sg13g2_fill_2
XFILLER_31_399 VPWR VGND sg13g2_fill_1
X_2761_ _3102_/B _3101_/A _3018_/A VPWR VGND sg13g2_xor2_1
XFILLER_77_4 VPWR VGND sg13g2_fill_1
X_4500_ _5194_/D hold828/X _3796_/Y _4509_/S VPWR VGND sg13g2_mux2_1
X_2692_ _2708_/A _5243_/Q _2938_/B VPWR VGND sg13g2_nand2_1
X_4431_ _4463_/B _3342_/B _3746_/B _4431_/B1 VPWR VGND sg13g2_o21ai_1
XFILLER_6_63 VPWR VGND sg13g2_decap_8
X_4362_ _5293_/D _3815_/Y hold812/X _4371_/S VPWR VGND sg13g2_mux2_1
Xfanout508 _3398_/B1 _3401_/B1 VPWR VGND sg13g2_buf_2
Xfanout519 _3671_/B1 _2690_/X VPWR VGND sg13g2_buf_1
X_4293_ _5350_/D _3989_/Y hold791/X _4294_/S VPWR VGND sg13g2_mux2_1
X_3313_ _3313_/Y _3313_/A _3313_/B VPWR VGND sg13g2_nor2_1
X_3244_ _3244_/X _3244_/A1 _4472_/B _3243_/Y VPWR VGND sg13g2_a21o_1
XFILLER_20_0 VPWR VGND sg13g2_decap_8
XFILLER_39_455 VPWR VGND sg13g2_fill_1
XFILLER_39_477 VPWR VGND sg13g2_decap_8
X_3175_ _4474_/A _3175_/A VPWR VGND sg13g2_inv_1
XFILLER_81_244 VPWR VGND sg13g2_fill_2
XFILLER_34_160 VPWR VGND sg13g2_decap_8
XFILLER_34_182 VPWR VGND sg13g2_fill_1
X_2959_ _2959_/X _2963_/B _2959_/B VPWR VGND sg13g2_or2_1
X_4629_ _4629_/Y _4638_/A _4629_/B _4629_/C VPWR VGND sg13g2_nor3_1
XFILLER_9_315 VPWR VGND sg13g2_decap_8
XFILLER_5_521 VPWR VGND sg13g2_decap_8
XFILLER_48_230 VPWR VGND sg13g2_decap_4
XFILLER_76_583 VPWR VGND sg13g2_fill_2
XFILLER_56_90 VPWR VGND sg13g2_fill_1
X_4980_ _4980_/Y _5142_/A VPWR VGND sg13g2_inv_1
XFILLER_63_288 VPWR VGND sg13g2_decap_8
XFILLER_16_193 VPWR VGND sg13g2_decap_8
X_3931_ _3932_/B _2618_/Y _3953_/A2 _3929_/Y _3930_/Y VPWR VGND sg13g2_a22oi_1
X_3862_ _3862_/Y _3945_/B _3737_/C _3739_/D _3739_/A VPWR VGND sg13g2_a22oi_1
X_2813_ _2813_/Y _2992_/B _3210_/C VPWR VGND sg13g2_nor2_1
XFILLER_31_196 VPWR VGND sg13g2_decap_4
X_3793_ _4480_/A _4088_/B _3706_/Y _3746_/Y _4041_/A _3792_/Y VPWR VGND sg13g2_a221oi_1
X_2744_ _2744_/X _4441_/C _3019_/B VPWR VGND sg13g2_and2_1
X_5463_ _5463_/X _5463_/A VPWR VGND sg13g2_buf_1
X_2675_ _4520_/B _4521_/A _4521_/B VPWR VGND sg13g2_nand2_1
X_5394_ _5394_/Q clkload9/A _5394_/D _5134_/Y VPWR VGND sg13g2_dfrbpq_1
X_4414_ _4414_/Y _4414_/A _4424_/S VPWR VGND sg13g2_nand2_1
Xfanout305 _4143_/A _4449_/B VPWR VGND sg13g2_buf_1
X_4345_ _5304_/D _3136_/Y hold674/X _4350_/S VPWR VGND sg13g2_mux2_1
Xfanout316 _3764_/A _4446_/A VPWR VGND sg13g2_buf_1
Xfanout327 _4178_/A2 _3063_/Y VPWR VGND sg13g2_buf_1
Xfanout338 _2974_/B _2856_/Y VPWR VGND sg13g2_buf_1
XFILLER_59_528 VPWR VGND sg13g2_decap_8
Xfanout349 _4452_/A _3686_/Y VPWR VGND sg13g2_buf_1
X_4276_ _4276_/Y _4355_/A _4276_/B VPWR VGND sg13g2_nand2_1
X_3227_ _3228_/B _3044_/D _3034_/Y _3269_/B VPWR VGND sg13g2_o21ai_1
X_3158_ _3158_/Y _3161_/A _3158_/B VPWR VGND sg13g2_xnor2_1
XFILLER_27_436 VPWR VGND sg13g2_fill_1
XFILLER_36_38 VPWR VGND sg13g2_decap_8
XFILLER_14_119 VPWR VGND sg13g2_decap_8
XFILLER_42_417 VPWR VGND sg13g2_decap_8
X_3089_ _4477_/A _3081_/B _3075_/Y _3088_/Y VPWR VGND sg13g2_o21ai_1
XFILLER_54_255 VPWR VGND sg13g2_fill_2
XFILLER_10_314 VPWR VGND sg13g2_decap_8
XFILLER_6_307 VPWR VGND sg13g2_decap_8
XFILLER_77_314 VPWR VGND sg13g2_decap_4
XFILLER_77_347 VPWR VGND sg13g2_fill_2
XFILLER_18_436 VPWR VGND sg13g2_decap_8
XFILLER_18_469 VPWR VGND sg13g2_decap_8
XFILLER_33_417 VPWR VGND sg13g2_fill_1
XFILLER_26_491 VPWR VGND sg13g2_decap_8
XFILLER_41_483 VPWR VGND sg13g2_decap_8
XFILLER_42_70 VPWR VGND sg13g2_decap_8
XFILLER_9_156 VPWR VGND sg13g2_decap_8
XFILLER_5_362 VPWR VGND sg13g2_decap_8
X_4130_ _4131_/C _4130_/A _4130_/B _4132_/A VPWR VGND sg13g2_and3_1
XFILLER_68_336 VPWR VGND sg13g2_decap_4
XFILLER_1_590 VPWR VGND sg13g2_decap_8
XFILLER_3_75 VPWR VGND sg13g2_decap_4
X_4061_ _4088_/C _4087_/B _4113_/C _4087_/A VPWR VGND sg13g2_o21ai_1
XFILLER_36_211 VPWR VGND sg13g2_fill_2
X_3012_ _3012_/Y _4210_/A1 _4201_/A _2998_/Y VPWR VGND sg13g2_o21ai_1
XFILLER_24_428 VPWR VGND sg13g2_fill_2
XFILLER_51_214 VPWR VGND sg13g2_decap_8
X_4963_ _4963_/Y _4964_/A VPWR VGND sg13g2_inv_1
X_3914_ _3914_/Y _3896_/A _3739_/A _3895_/A _4001_/B2 VPWR VGND sg13g2_a22oi_1
X_4894_ _4896_/B _4894_/A _4901_/C VPWR VGND sg13g2_xnor2_1
X_3845_ _3845_/Y _4095_/A _3763_/B _3896_/A VPWR VGND sg13g2_a21oi_1
X_3776_ _3920_/B _3776_/A _3938_/B _4452_/B _4158_/B VPWR VGND sg13g2_nand4_1
X_2727_ _2727_/Y _2727_/A _2727_/B _2727_/C _2727_/D VPWR VGND sg13g2_nand4_1
X_5446_ _5446_/X _5446_/A VPWR VGND sg13g2_buf_1
X_2658_ _2658_/Y _4490_/A _3679_/A VPWR VGND sg13g2_nand2_1
X_5377_ _5377_/Q clkload9/A _5377_/D _5117_/Y VPWR VGND sg13g2_dfrbpq_1
X_2589_ _2589_/Y _2589_/A VPWR VGND sg13g2_inv_1
X_4328_ _5318_/D _3989_/Y hold714/X _4335_/B VPWR VGND sg13g2_mux2_1
X_4259_ _4259_/Y _4338_/A _4276_/B VPWR VGND sg13g2_nand2_1
XFILLER_27_200 VPWR VGND sg13g2_decap_8
XFILLER_67_380 VPWR VGND sg13g2_fill_2
XFILLER_42_203 VPWR VGND sg13g2_decap_8
XFILLER_63_47 VPWR VGND sg13g2_decap_4
XFILLER_70_556 VPWR VGND sg13g2_decap_8
XFILLER_12_40 VPWR VGND sg13g2_decap_8
XFILLER_6_159 VPWR VGND sg13g2_fill_1
XFILLER_6_137 VPWR VGND sg13g2_fill_2
XFILLER_2_387 VPWR VGND sg13g2_fill_1
XFILLER_77_122 VPWR VGND sg13g2_decap_8
XFILLER_18_211 VPWR VGND sg13g2_decap_8
XFILLER_80_309 VPWR VGND sg13g2_fill_2
XFILLER_33_225 VPWR VGND sg13g2_fill_2
XFILLER_14_483 VPWR VGND sg13g2_decap_8
X_3630_ _3631_/D _5290_/Q _3688_/B1 _3464_/B _5354_/Q VPWR VGND sg13g2_a22oi_1
X_3561_ _3563_/B _4143_/A _3567_/B VPWR VGND sg13g2_or2_1
X_5300_ _5300_/Q _5430_/CLK _5300_/D _5040_/Y VPWR VGND sg13g2_dfrbpq_1
X_3492_ _3494_/C _5378_/Q _3492_/B VPWR VGND sg13g2_nand2_1
X_5231_ _5231_/Q _5392_/CLK _5231_/D _4971_/Y VPWR VGND sg13g2_dfrbpq_1
X_5162_ _5162_/Y _5162_/A VPWR VGND sg13g2_inv_1
X_5093_ _5093_/Y _5125_/A VPWR VGND sg13g2_inv_1
X_4113_ _4113_/X _4131_/A _4113_/B _4113_/C VPWR VGND sg13g2_or3_1
XFILLER_68_133 VPWR VGND sg13g2_decap_8
XFILLER_49_380 VPWR VGND sg13g2_decap_8
XFILLER_49_391 VPWR VGND sg13g2_decap_8
X_4044_ _4044_/Y _4450_/B _4067_/A VPWR VGND sg13g2_xnor2_1
XFILLER_64_361 VPWR VGND sg13g2_decap_8
XFILLER_24_225 VPWR VGND sg13g2_fill_1
XFILLER_24_269 VPWR VGND sg13g2_decap_8
XFILLER_33_28 VPWR VGND sg13g2_fill_2
X_4946_ _4946_/Y _4951_/A VPWR VGND sg13g2_inv_1
XFILLER_20_431 VPWR VGND sg13g2_fill_1
X_4877_ _4879_/B _4877_/A _4884_/B VPWR VGND sg13g2_nor2b_1
X_3828_ _3828_/Y _3847_/B _3844_/B _3878_/A VPWR VGND sg13g2_a21oi_1
X_3759_ _3895_/B _3936_/B _3920_/A _3938_/B _3996_/A VPWR VGND sg13g2_nor4_1
X_5429_ _5429_/Q _5435_/CLK _5429_/D _5169_/Y VPWR VGND sg13g2_dfrbpq_1
XFILLER_59_111 VPWR VGND sg13g2_fill_1
XFILLER_59_100 VPWR VGND sg13g2_decap_8
XFILLER_58_36 VPWR VGND sg13g2_fill_1
XFILLER_59_122 VPWR VGND sg13g2_decap_8
XFILLER_47_317 VPWR VGND sg13g2_fill_2
XFILLER_75_615 VPWR VGND sg13g2_decap_8
XFILLER_74_125 VPWR VGND sg13g2_fill_2
XFILLER_74_79 VPWR VGND sg13g2_decap_8
XFILLER_55_394 VPWR VGND sg13g2_decap_8
XFILLER_15_269 VPWR VGND sg13g2_decap_4
XFILLER_43_545 VPWR VGND sg13g2_decap_8
XFILLER_70_397 VPWR VGND sg13g2_fill_2
XFILLER_70_386 VPWR VGND sg13g2_decap_8
XFILLER_23_50 VPWR VGND sg13g2_fill_2
XFILLER_23_94 VPWR VGND sg13g2_decap_4
XFILLER_7_435 VPWR VGND sg13g2_decap_8
XFILLER_66_626 VPWR VGND sg13g2_fill_2
XFILLER_66_615 VPWR VGND sg13g2_decap_8
XFILLER_0_32 VPWR VGND sg13g2_decap_8
XFILLER_19_564 VPWR VGND sg13g2_fill_2
XFILLER_19_575 VPWR VGND sg13g2_fill_1
XFILLER_34_501 VPWR VGND sg13g2_decap_8
XFILLER_81_618 VPWR VGND sg13g2_decap_8
XFILLER_61_320 VPWR VGND sg13g2_decap_8
XFILLER_0_98 VPWR VGND sg13g2_decap_8
X_4800_ _4800_/Y _4814_/A _4800_/B VPWR VGND sg13g2_nor2_1
XFILLER_34_589 VPWR VGND sg13g2_decap_8
X_2992_ _2994_/D _3253_/B _2992_/B _2992_/C _2992_/D VPWR VGND sg13g2_nand4_1
X_4731_ _4731_/Y _4724_/A _4724_/B _4725_/A VPWR VGND sg13g2_o21ai_1
X_4662_ _4663_/B _4654_/A _4654_/B _4651_/Y VPWR VGND sg13g2_o21ai_1
X_3613_ _5460_/A _3613_/A _3611_/Y VPWR VGND sg13g2_nor2b_1
X_4593_ _4598_/B _5454_/A _4594_/B VPWR VGND sg13g2_nand2b_1
X_3544_ _3715_/A _3542_/B _3542_/C _4116_/B VPWR VGND sg13g2_o21ai_1
X_3475_ _3477_/C _5184_/Q _3456_/B _3581_/B _5380_/Q VPWR VGND sg13g2_a22oi_1
X_5214_ _5214_/Q _5216_/CLK _5214_/D _4954_/Y VPWR VGND sg13g2_dfrbpq_1
XFILLER_28_39 VPWR VGND sg13g2_decap_8
X_5145_ _5145_/Y _5145_/A VPWR VGND sg13g2_inv_1
X_5076_ _5076_/Y _5076_/A VPWR VGND sg13g2_inv_1
XFILLER_37_350 VPWR VGND sg13g2_fill_2
X_4027_ _4027_/Y _4448_/C _4043_/B VPWR VGND sg13g2_xnor2_1
XFILLER_71_106 VPWR VGND sg13g2_fill_1
XFILLER_25_512 VPWR VGND sg13g2_decap_8
XFILLER_44_16 VPWR VGND sg13g2_fill_2
XFILLER_44_38 VPWR VGND sg13g2_fill_1
XFILLER_25_589 VPWR VGND sg13g2_decap_4
XFILLER_40_504 VPWR VGND sg13g2_decap_8
XFILLER_40_559 VPWR VGND sg13g2_decap_8
X_4929_ _4929_/Y _5125_/A VPWR VGND sg13g2_inv_1
XFILLER_20_283 VPWR VGND sg13g2_decap_4
XFILLER_4_427 VPWR VGND sg13g2_fill_2
XFILLER_4_449 VPWR VGND sg13g2_decap_8
XFILLER_69_46 VPWR VGND sg13g2_fill_1
XFILLER_48_637 VPWR VGND sg13g2_fill_2
XFILLER_47_158 VPWR VGND sg13g2_decap_8
XFILLER_63_618 VPWR VGND sg13g2_decap_8
XFILLER_28_372 VPWR VGND sg13g2_fill_1
XFILLER_31_504 VPWR VGND sg13g2_decap_4
XFILLER_31_537 VPWR VGND sg13g2_decap_8
XFILLER_11_261 VPWR VGND sg13g2_decap_8
XFILLER_50_92 VPWR VGND sg13g2_fill_1
X_3260_ _3262_/C _4139_/A1 _3251_/B _3254_/B _3120_/A _3254_/Y VPWR VGND sg13g2_a221oi_1
XFILLER_39_604 VPWR VGND sg13g2_decap_8
X_3191_ _3192_/S _3191_/A _3191_/B VPWR VGND sg13g2_xor2_1
XFILLER_66_423 VPWR VGND sg13g2_decap_4
XFILLER_54_618 VPWR VGND sg13g2_decap_4
XFILLER_19_372 VPWR VGND sg13g2_fill_2
XFILLER_53_128 VPWR VGND sg13g2_decap_8
XFILLER_62_640 VPWR VGND sg13g2_fill_2
XFILLER_34_375 VPWR VGND sg13g2_decap_8
XFILLER_61_183 VPWR VGND sg13g2_fill_2
XFILLER_61_172 VPWR VGND sg13g2_decap_8
X_4714_ _4716_/B _4700_/B _4729_/B _4729_/A VPWR VGND sg13g2_a21oi_1
X_2975_ _3206_/B _3210_/B _3205_/B VPWR VGND sg13g2_and2_1
X_4645_ _4646_/B _4495_/A _4495_/B _4493_/Y VPWR VGND sg13g2_o21ai_1
Xhold700 hold700/X _5358_/Q VPWR VGND sg13g2_dlygate4sd3_1
Xhold711 hold711/X _5340_/Q VPWR VGND sg13g2_dlygate4sd3_1
X_4576_ _4576_/Y _5449_/A _4571_/B _5450_/A VPWR VGND sg13g2_o21ai_1
Xhold722 hold722/X _5270_/Q VPWR VGND sg13g2_dlygate4sd3_1
Xhold733 hold733/X _5419_/Q VPWR VGND sg13g2_dlygate4sd3_1
Xhold744 hold744/X _5257_/Q VPWR VGND sg13g2_dlygate4sd3_1
Xhold755 hold755/X _5266_/Q VPWR VGND sg13g2_dlygate4sd3_1
X_3527_ _3531_/B _5376_/Q _3547_/B1 _3508_/B _5408_/Q VPWR VGND sg13g2_a22oi_1
Xhold788 hold788/X _5256_/Q VPWR VGND sg13g2_dlygate4sd3_1
Xhold777 hold777/X _5426_/Q VPWR VGND sg13g2_dlygate4sd3_1
Xhold766 hold766/X _5341_/Q VPWR VGND sg13g2_dlygate4sd3_1
XFILLER_39_38 VPWR VGND sg13g2_fill_1
Xhold799 hold799/X _5255_/Q VPWR VGND sg13g2_dlygate4sd3_1
X_3458_ _3460_/C _5315_/Q _3683_/A2 _3508_/B _5411_/Q VPWR VGND sg13g2_a22oi_1
X_3389_ _3389_/Y _5310_/Q _3689_/A2 _3464_/B _5342_/Q _3388_/X VPWR VGND sg13g2_a221oi_1
XFILLER_76_209 VPWR VGND sg13g2_decap_8
X_5128_ _5128_/Y _5161_/A VPWR VGND sg13g2_inv_1
XFILLER_69_272 VPWR VGND sg13g2_decap_8
XFILLER_29_158 VPWR VGND sg13g2_decap_8
X_5059_ _5059_/Y _5162_/A VPWR VGND sg13g2_inv_1
XFILLER_25_342 VPWR VGND sg13g2_decap_8
XFILLER_71_36 VPWR VGND sg13g2_fill_1
XFILLER_40_345 VPWR VGND sg13g2_decap_8
XFILLER_40_367 VPWR VGND sg13g2_decap_8
XFILLER_71_69 VPWR VGND sg13g2_fill_1
XFILLER_4_246 VPWR VGND sg13g2_decap_4
XFILLER_20_73 VPWR VGND sg13g2_fill_1
XFILLER_0_441 VPWR VGND sg13g2_fill_2
XFILLER_29_82 VPWR VGND sg13g2_decap_8
XFILLER_75_264 VPWR VGND sg13g2_decap_8
XFILLER_35_117 VPWR VGND sg13g2_decap_4
XFILLER_75_297 VPWR VGND sg13g2_fill_1
XFILLER_63_426 VPWR VGND sg13g2_fill_2
XFILLER_28_180 VPWR VGND sg13g2_fill_1
XFILLER_16_375 VPWR VGND sg13g2_decap_8
XFILLER_45_70 VPWR VGND sg13g2_decap_8
XFILLER_31_356 VPWR VGND sg13g2_decap_8
X_2760_ _3081_/B _4441_/C _3019_/B VPWR VGND sg13g2_xnor2_1
X_2691_ _2691_/X _2694_/B _2817_/C VPWR VGND sg13g2_and2_1
XFILLER_8_563 VPWR VGND sg13g2_decap_4
XFILLER_61_80 VPWR VGND sg13g2_decap_8
X_4430_ _4430_/Y _3337_/Y _3706_/B _4460_/B VPWR VGND sg13g2_o21ai_1
XFILLER_6_42 VPWR VGND sg13g2_decap_8
X_4361_ _5294_/D _3796_/Y hold781/X _4371_/S VPWR VGND sg13g2_mux2_1
Xfanout509 _3401_/B1 _2713_/X VPWR VGND sg13g2_buf_1
X_4292_ _5351_/D _3953_/Y hold652/X _4299_/S VPWR VGND sg13g2_mux2_1
X_3312_ _3315_/C _3313_/A _3312_/B VPWR VGND sg13g2_nand2b_1
XFILLER_39_401 VPWR VGND sg13g2_fill_1
X_3243_ _3243_/Y input91/X _3244_/A1 _3065_/B VPWR VGND sg13g2_o21ai_1
XFILLER_13_0 VPWR VGND sg13g2_decap_4
X_3174_ _3175_/A _3269_/B _3158_/Y _3161_/Y _4133_/A _3173_/Y VPWR VGND sg13g2_a221oi_1
XFILLER_54_415 VPWR VGND sg13g2_fill_2
XFILLER_26_139 VPWR VGND sg13g2_decap_8
XFILLER_54_448 VPWR VGND sg13g2_decap_8
XFILLER_22_301 VPWR VGND sg13g2_decap_8
XFILLER_22_323 VPWR VGND sg13g2_decap_8
XFILLER_62_481 VPWR VGND sg13g2_decap_8
XFILLER_22_367 VPWR VGND sg13g2_decap_8
XFILLER_10_529 VPWR VGND sg13g2_decap_8
XFILLER_22_378 VPWR VGND sg13g2_fill_2
X_2958_ _4457_/B _2963_/B _2959_/B VPWR VGND sg13g2_nor2_1
X_4628_ _4628_/Y _4628_/A VPWR VGND sg13g2_inv_1
X_2889_ _2889_/Y _2887_/A _2887_/B _2974_/C VPWR VGND sg13g2_o21ai_1
X_4559_ _4559_/Y _4724_/A _4559_/B VPWR VGND sg13g2_nand2_1
XFILLER_66_58 VPWR VGND sg13g2_decap_8
XFILLER_17_106 VPWR VGND sg13g2_fill_2
XFILLER_72_212 VPWR VGND sg13g2_decap_8
XFILLER_57_297 VPWR VGND sg13g2_fill_2
XFILLER_25_161 VPWR VGND sg13g2_decap_8
XFILLER_53_481 VPWR VGND sg13g2_fill_1
XFILLER_53_470 VPWR VGND sg13g2_fill_2
XFILLER_40_142 VPWR VGND sg13g2_decap_4
XFILLER_5_511 VPWR VGND sg13g2_decap_4
XFILLER_31_72 VPWR VGND sg13g2_decap_8
XFILLER_31_83 VPWR VGND sg13g2_fill_2
XFILLER_5_555 VPWR VGND sg13g2_decap_8
XFILLER_5_588 VPWR VGND sg13g2_decap_4
XFILLER_5_566 VPWR VGND sg13g2_fill_1
XFILLER_68_507 VPWR VGND sg13g2_fill_2
XFILLER_48_286 VPWR VGND sg13g2_fill_2
XFILLER_36_459 VPWR VGND sg13g2_decap_8
XFILLER_48_297 VPWR VGND sg13g2_decap_4
XFILLER_23_109 VPWR VGND sg13g2_decap_8
X_3930_ _3930_/Y _3589_/A _3064_/A _3953_/A2 VPWR VGND sg13g2_a21oi_1
XFILLER_31_131 VPWR VGND sg13g2_decap_4
XFILLER_31_142 VPWR VGND sg13g2_fill_2
X_3861_ _5419_/D hold733/X _3860_/Y _4013_/S VPWR VGND sg13g2_mux2_1
X_3792_ _3792_/Y _3787_/Y _3792_/B _3792_/C VPWR VGND sg13g2_nand3b_1
X_2812_ _3210_/C _4670_/A _5441_/A _3403_/S VPWR VGND sg13g2_mux2_1
X_2743_ _2743_/X _4441_/C _3019_/B VPWR VGND sg13g2_or2_1
X_5462_ _5462_/X _5462_/A VPWR VGND sg13g2_buf_1
X_2674_ _2965_/C _3896_/A _3102_/A VPWR VGND sg13g2_nor2_1
X_5393_ _5393_/Q _5434_/CLK _5393_/D _5133_/Y VPWR VGND sg13g2_dfrbpq_1
X_4413_ _5244_/D _4261_/A hold681/X _4427_/B VPWR VGND sg13g2_mux2_1
X_4344_ _5305_/D _4224_/A hold738/X _4359_/S VPWR VGND sg13g2_mux2_1
Xfanout306 _4449_/B _3552_/Y VPWR VGND sg13g2_buf_1
Xfanout317 _4446_/A _3347_/Y VPWR VGND sg13g2_buf_1
Xfanout328 _4001_/B2 _3847_/A VPWR VGND sg13g2_buf_1
Xfanout339 _4440_/B _2856_/Y VPWR VGND sg13g2_buf_1
X_4275_ _5363_/D _2552_/Y _4280_/B _4274_/Y VPWR VGND sg13g2_o21ai_1
X_3226_ _3242_/A _3226_/A _4111_/A _3226_/C VPWR VGND sg13g2_nor3_1
XFILLER_67_551 VPWR VGND sg13g2_decap_8
XFILLER_27_415 VPWR VGND sg13g2_decap_8
X_3157_ _3158_/B _3157_/A _3157_/B VPWR VGND sg13g2_nor2_1
XFILLER_14_109 VPWR VGND sg13g2_fill_1
X_3088_ _3088_/Y _3081_/B _3077_/Y _3078_/Y _4441_/A _3087_/X VPWR VGND sg13g2_a221oi_1
XFILLER_23_632 VPWR VGND sg13g2_fill_2
XFILLER_35_481 VPWR VGND sg13g2_decap_4
XFILLER_23_643 VPWR VGND sg13g2_fill_1
XFILLER_52_38 VPWR VGND sg13g2_decap_8
XFILLER_50_462 VPWR VGND sg13g2_decap_8
XFILLER_52_49 VPWR VGND sg13g2_fill_1
XFILLER_10_359 VPWR VGND sg13g2_decap_8
XFILLER_50_495 VPWR VGND sg13g2_decap_8
XFILLER_2_514 VPWR VGND sg13g2_decap_8
XFILLER_58_595 VPWR VGND sg13g2_decap_8
XFILLER_73_521 VPWR VGND sg13g2_decap_8
XFILLER_14_632 VPWR VGND sg13g2_fill_2
XFILLER_60_259 VPWR VGND sg13g2_decap_8
XFILLER_13_153 VPWR VGND sg13g2_fill_2
XFILLER_9_135 VPWR VGND sg13g2_decap_8
XFILLER_3_21 VPWR VGND sg13g2_decap_8
X_4060_ _5411_/D hold694/X _4059_/Y _4224_/B VPWR VGND sg13g2_mux2_1
X_3011_ _3011_/Y _3011_/A _4116_/A VPWR VGND sg13g2_nor2_1
XFILLER_36_223 VPWR VGND sg13g2_fill_1
XFILLER_51_204 VPWR VGND sg13g2_fill_1
X_4962_ _4962_/Y _4964_/A VPWR VGND sg13g2_inv_1
X_4893_ _5221_/D _4914_/A _4889_/B _4892_/Y VPWR VGND sg13g2_o21ai_1
X_3913_ _3921_/B _3920_/A _3913_/B VPWR VGND sg13g2_xnor2_1
XFILLER_32_473 VPWR VGND sg13g2_decap_8
X_3844_ _3851_/A _3878_/A _3844_/B _3844_/C VPWR VGND sg13g2_nor3_1
XFILLER_32_495 VPWR VGND sg13g2_decap_4
X_3775_ _3976_/B _3776_/A _4452_/B _4158_/B VPWR VGND sg13g2_nand3_1
X_2726_ _2727_/D _5371_/Q _2927_/A2 _3371_/B1 _5339_/Q VPWR VGND sg13g2_a22oi_1
X_5445_ _5445_/X _5445_/A VPWR VGND sg13g2_buf_1
X_2657_ _2657_/Y _2956_/B _3559_/S VPWR VGND sg13g2_nor2_1
X_5376_ _5376_/Q _5424_/CLK _5376_/D _5116_/Y VPWR VGND sg13g2_dfrbpq_1
X_2588_ _2588_/Y _2588_/A VPWR VGND sg13g2_inv_1
X_4327_ _5319_/D _3953_/Y hold686/X _4329_/S VPWR VGND sg13g2_mux2_1
X_4258_ _5374_/D hold661/X _4178_/Y _4258_/S VPWR VGND sg13g2_mux2_1
X_3209_ _3217_/A _3209_/A1 _3208_/B _3208_/Y VPWR VGND sg13g2_a21oi_1
X_4189_ _4192_/C _4208_/A _3721_/B _4188_/Y VPWR VGND sg13g2_o21ai_1
XFILLER_55_521 VPWR VGND sg13g2_decap_4
XFILLER_15_429 VPWR VGND sg13g2_decap_8
XFILLER_27_289 VPWR VGND sg13g2_decap_4
XFILLER_55_598 VPWR VGND sg13g2_decap_8
XFILLER_70_579 VPWR VGND sg13g2_decap_8
XFILLER_10_123 VPWR VGND sg13g2_decap_8
XFILLER_11_635 VPWR VGND sg13g2_decap_8
XFILLER_2_344 VPWR VGND sg13g2_decap_8
XFILLER_2_366 VPWR VGND sg13g2_decap_4
XFILLER_78_646 VPWR VGND sg13g2_decap_4
XFILLER_77_156 VPWR VGND sg13g2_decap_4
XFILLER_77_145 VPWR VGND sg13g2_fill_1
XFILLER_73_340 VPWR VGND sg13g2_fill_2
XFILLER_33_204 VPWR VGND sg13g2_decap_8
XFILLER_73_373 VPWR VGND sg13g2_fill_1
XFILLER_61_546 VPWR VGND sg13g2_fill_2
XFILLER_14_462 VPWR VGND sg13g2_decap_8
XFILLER_41_270 VPWR VGND sg13g2_fill_2
X_3560_ _4110_/B _4143_/A _3567_/B VPWR VGND sg13g2_nand2_1
X_5230_ _5230_/Q clkload0/A _5230_/D _4970_/Y VPWR VGND sg13g2_dfrbpq_1
X_3491_ _3494_/B _5182_/Q _3456_/B _2689_/Y VPWR VGND sg13g2_a21oi_1
XFILLER_5_160 VPWR VGND sg13g2_decap_8
X_5161_ _5161_/Y _5161_/A VPWR VGND sg13g2_inv_1
XFILLER_69_613 VPWR VGND sg13g2_fill_1
XFILLER_68_112 VPWR VGND sg13g2_decap_8
X_5092_ _5092_/Y _5092_/A VPWR VGND sg13g2_inv_1
X_4112_ _4112_/Y _4112_/A _4112_/B _4131_/B VPWR VGND sg13g2_nor3_1
X_4043_ _4054_/B _4043_/A _4043_/B _4043_/C VPWR VGND sg13g2_nand3_1
XFILLER_37_565 VPWR VGND sg13g2_decap_8
XFILLER_64_340 VPWR VGND sg13g2_decap_8
XFILLER_52_524 VPWR VGND sg13g2_fill_2
XFILLER_64_395 VPWR VGND sg13g2_decap_8
X_4945_ _4945_/Y _4951_/A VPWR VGND sg13g2_inv_1
XFILLER_52_557 VPWR VGND sg13g2_decap_8
XFILLER_20_410 VPWR VGND sg13g2_decap_8
X_4876_ _4884_/B _4876_/A _4876_/B _4876_/C VPWR VGND sg13g2_nand3_1
XFILLER_20_465 VPWR VGND sg13g2_fill_2
X_3827_ _3827_/X _3847_/B _3844_/B VPWR VGND sg13g2_or2_1
XFILLER_20_487 VPWR VGND sg13g2_decap_8
X_3758_ _3913_/B _3936_/B _3938_/B _3996_/A VPWR VGND sg13g2_nor3_1
X_2709_ _2710_/B _2723_/C _2723_/B VPWR VGND sg13g2_nor2b_1
X_3689_ _3691_/C _5323_/Q _3689_/A2 _3689_/B1 _5419_/Q VPWR VGND sg13g2_a22oi_1
X_5428_ _5428_/Q _5435_/CLK _5428_/D _5168_/Y VPWR VGND sg13g2_dfrbpq_1
X_5359_ _5359_/Q clkload9/A _5359_/D _5099_/Y VPWR VGND sg13g2_dfrbpq_1
XFILLER_28_521 VPWR VGND sg13g2_fill_1
XFILLER_74_137 VPWR VGND sg13g2_fill_2
XFILLER_74_58 VPWR VGND sg13g2_decap_8
XFILLER_15_204 VPWR VGND sg13g2_decap_8
XFILLER_28_598 VPWR VGND sg13g2_decap_8
XFILLER_43_524 VPWR VGND sg13g2_fill_2
XFILLER_55_362 VPWR VGND sg13g2_decap_8
XFILLER_11_410 VPWR VGND sg13g2_decap_8
XFILLER_30_229 VPWR VGND sg13g2_decap_4
XFILLER_11_454 VPWR VGND sg13g2_decap_4
XFILLER_7_414 VPWR VGND sg13g2_decap_8
XFILLER_11_498 VPWR VGND sg13g2_decap_8
XFILLER_3_631 VPWR VGND sg13g2_decap_8
XFILLER_78_465 VPWR VGND sg13g2_decap_4
XFILLER_0_11 VPWR VGND sg13g2_decap_8
XFILLER_48_81 VPWR VGND sg13g2_fill_1
XFILLER_65_137 VPWR VGND sg13g2_fill_1
XFILLER_19_543 VPWR VGND sg13g2_decap_8
XFILLER_19_598 VPWR VGND sg13g2_decap_8
XFILLER_46_373 VPWR VGND sg13g2_decap_4
XFILLER_34_568 VPWR VGND sg13g2_decap_8
XFILLER_61_343 VPWR VGND sg13g2_decap_4
X_2991_ _2992_/D _4435_/A _4436_/A VPWR VGND sg13g2_nor2_1
XFILLER_14_270 VPWR VGND sg13g2_fill_1
X_4730_ _4730_/Y _4730_/A _4730_/B _4730_/C VPWR VGND sg13g2_nor3_1
X_4661_ _4663_/A _4659_/Y _4661_/B VPWR VGND sg13g2_nand2b_1
XFILLER_9_75 VPWR VGND sg13g2_decap_8
X_3612_ _3613_/A _5255_/Q _4603_/A1 _2754_/B VPWR VGND sg13g2_a21oi_1
X_4592_ _4592_/Y _4623_/C _4590_/Y _4591_/Y VPWR VGND sg13g2_o21ai_1
X_3543_ _3731_/A _4116_/B _3569_/B VPWR VGND sg13g2_and2_1
XFILLER_43_0 VPWR VGND sg13g2_decap_4
X_3474_ _3477_/B _5316_/Q _3683_/A2 _3683_/B1 _5348_/Q VPWR VGND sg13g2_a22oi_1
XFILLER_6_491 VPWR VGND sg13g2_decap_8
X_5213_ _5213_/Q _5216_/CLK _5213_/D _4953_/Y VPWR VGND sg13g2_dfrbpq_1
X_5144_ _5144_/Y _5144_/A VPWR VGND sg13g2_inv_1
XFILLER_28_29 VPWR VGND sg13g2_fill_1
XFILLER_29_307 VPWR VGND sg13g2_decap_8
XFILLER_69_487 VPWR VGND sg13g2_decap_8
XFILLER_57_605 VPWR VGND sg13g2_fill_2
X_5075_ _5075_/Y _5172_/A VPWR VGND sg13g2_inv_1
XFILLER_57_638 VPWR VGND sg13g2_decap_8
X_4026_ _4026_/Y _3239_/A _4018_/Y _4025_/Y VPWR VGND sg13g2_o21ai_1
XFILLER_52_321 VPWR VGND sg13g2_decap_8
XFILLER_52_365 VPWR VGND sg13g2_fill_1
X_4928_ _4928_/Y _5159_/A VPWR VGND sg13g2_inv_1
X_4859_ _4869_/B _4913_/A _4860_/B VPWR VGND sg13g2_nand2_1
XFILLER_0_612 VPWR VGND sg13g2_decap_8
XFILLER_48_616 VPWR VGND sg13g2_fill_2
XFILLER_48_627 VPWR VGND sg13g2_fill_1
XFILLER_47_137 VPWR VGND sg13g2_decap_8
XFILLER_75_424 VPWR VGND sg13g2_fill_2
XFILLER_16_502 VPWR VGND sg13g2_decap_8
XFILLER_55_170 VPWR VGND sg13g2_decap_4
XFILLER_16_546 VPWR VGND sg13g2_fill_2
XFILLER_28_395 VPWR VGND sg13g2_decap_8
XFILLER_43_354 VPWR VGND sg13g2_fill_1
XFILLER_24_590 VPWR VGND sg13g2_fill_1
XFILLER_34_94 VPWR VGND sg13g2_decap_8
XFILLER_50_71 VPWR VGND sg13g2_decap_8
XFILLER_7_277 VPWR VGND sg13g2_fill_1
XFILLER_3_450 VPWR VGND sg13g2_decap_4
XFILLER_3_494 VPWR VGND sg13g2_fill_1
X_3190_ _3193_/B _3190_/A _3190_/B _3190_/C _3190_/D VPWR VGND sg13g2_nor4_1
XFILLER_66_402 VPWR VGND sg13g2_decap_8
XFILLER_38_137 VPWR VGND sg13g2_decap_4
XFILLER_66_468 VPWR VGND sg13g2_fill_2
XFILLER_66_457 VPWR VGND sg13g2_decap_8
XFILLER_19_351 VPWR VGND sg13g2_decap_8
XFILLER_34_354 VPWR VGND sg13g2_decap_8
XFILLER_22_538 VPWR VGND sg13g2_decap_4
X_2974_ _3205_/B _4439_/B _2974_/B _2974_/C _2974_/D VPWR VGND sg13g2_and4_1
X_4713_ _4729_/B _2575_/A _4695_/Y _4705_/B _4706_/A VPWR VGND sg13g2_a22oi_1
X_4644_ _4646_/A _4644_/A _5195_/Q VPWR VGND sg13g2_xnor2_1
Xhold701 hold701/X _5242_/Q VPWR VGND sg13g2_dlygate4sd3_1
Xhold712 hold712/X _5402_/Q VPWR VGND sg13g2_dlygate4sd3_1
X_4575_ _4584_/C _5450_/A _5449_/A _4575_/C _4575_/D VPWR VGND sg13g2_or4_1
Xhold723 hold723/X _5250_/Q VPWR VGND sg13g2_dlygate4sd3_1
Xhold734 hold734/X _5181_/Q VPWR VGND sg13g2_dlygate4sd3_1
Xhold745 hold745/X _5413_/Q VPWR VGND sg13g2_dlygate4sd3_1
X_3526_ _3531_/A _5248_/Q _3685_/B VPWR VGND sg13g2_nand2_1
XFILLER_1_409 VPWR VGND sg13g2_fill_2
Xhold778 hold778/X _5352_/Q VPWR VGND sg13g2_dlygate4sd3_1
Xhold767 hold767/X _5268_/Q VPWR VGND sg13g2_dlygate4sd3_1
Xhold756 hold756/X _5288_/Q VPWR VGND sg13g2_dlygate4sd3_1
Xhold789 hold789/X _5265_/Q VPWR VGND sg13g2_dlygate4sd3_1
X_3457_ _3460_/B _5347_/Q _3683_/B1 _3684_/B1 _5283_/Q VPWR VGND sg13g2_a22oi_1
X_3388_ _3388_/X _5178_/Q _3627_/B _2712_/Y VPWR VGND sg13g2_a21o_1
X_5127_ _5127_/Y _5159_/A VPWR VGND sg13g2_inv_1
X_5058_ _5058_/Y _5159_/A VPWR VGND sg13g2_inv_1
XFILLER_57_446 VPWR VGND sg13g2_decap_8
X_4009_ _4009_/Y _2610_/Y _2685_/B _4009_/B1 VPWR VGND sg13g2_a21oi_1
XFILLER_25_387 VPWR VGND sg13g2_decap_8
XFILLER_52_195 VPWR VGND sg13g2_decap_8
XFILLER_80_493 VPWR VGND sg13g2_fill_1
XFILLER_21_560 VPWR VGND sg13g2_fill_2
XFILLER_21_593 VPWR VGND sg13g2_fill_1
XFILLER_4_203 VPWR VGND sg13g2_decap_8
XFILLER_20_52 VPWR VGND sg13g2_decap_8
XFILLER_0_431 VPWR VGND sg13g2_fill_1
XFILLER_48_402 VPWR VGND sg13g2_fill_2
XFILLER_0_486 VPWR VGND sg13g2_decap_8
XFILLER_29_61 VPWR VGND sg13g2_decap_8
XFILLER_48_424 VPWR VGND sg13g2_fill_2
XFILLER_75_243 VPWR VGND sg13g2_decap_8
XFILLER_16_321 VPWR VGND sg13g2_decap_4
XFILLER_44_641 VPWR VGND sg13g2_fill_2
XFILLER_43_173 VPWR VGND sg13g2_fill_2
XFILLER_71_493 VPWR VGND sg13g2_decap_8
XFILLER_8_520 VPWR VGND sg13g2_decap_8
X_2690_ _2690_/X _2704_/C _2704_/B VPWR VGND sg13g2_or2_1
XFILLER_8_542 VPWR VGND sg13g2_decap_8
X_4360_ _4360_/Y _4360_/A _4360_/B _4394_/C VPWR VGND sg13g2_nand3_1
X_3311_ _3312_/B _3878_/A _3921_/A _4116_/A VPWR VGND sg13g2_nand3_1
X_4291_ _5352_/D _3932_/B hold778/X _4299_/S VPWR VGND sg13g2_mux2_1
X_3242_ _4472_/B _3242_/A _3242_/B _3242_/C _3242_/D VPWR VGND sg13g2_nor4_1
XFILLER_79_560 VPWR VGND sg13g2_decap_8
XFILLER_39_413 VPWR VGND sg13g2_decap_8
X_3173_ _3173_/Y _3170_/Y _3173_/B VPWR VGND sg13g2_nand2b_1
XFILLER_27_608 VPWR VGND sg13g2_decap_8
XFILLER_39_446 VPWR VGND sg13g2_decap_8
XFILLER_66_243 VPWR VGND sg13g2_fill_2
XFILLER_26_107 VPWR VGND sg13g2_decap_8
XFILLER_27_619 VPWR VGND sg13g2_fill_2
XFILLER_54_427 VPWR VGND sg13g2_decap_8
XFILLER_19_170 VPWR VGND sg13g2_fill_1
XFILLER_47_490 VPWR VGND sg13g2_decap_8
XFILLER_81_246 VPWR VGND sg13g2_fill_1
XFILLER_81_224 VPWR VGND sg13g2_fill_2
XFILLER_34_173 VPWR VGND sg13g2_fill_1
XFILLER_50_633 VPWR VGND sg13g2_decap_8
X_2957_ _2959_/B _4490_/A _4185_/A VPWR VGND sg13g2_nor2_1
X_2888_ _3289_/B _3313_/A _3313_/B VPWR VGND sg13g2_and2_1
X_4627_ _4628_/A _4627_/A _4627_/B VPWR VGND sg13g2_and2_1
X_4558_ _4558_/X _4564_/C _4556_/X _4561_/A VPWR VGND sg13g2_a21o_1
X_4489_ _4490_/B _5228_/Q _4489_/B VPWR VGND sg13g2_nor2_1
X_3509_ _3512_/B _5377_/Q _3492_/B _2689_/Y VPWR VGND sg13g2_a21oi_1
XFILLER_57_210 VPWR VGND sg13g2_fill_2
XFILLER_18_608 VPWR VGND sg13g2_decap_8
XFILLER_66_37 VPWR VGND sg13g2_decap_8
XFILLER_57_243 VPWR VGND sg13g2_fill_1
XFILLER_18_619 VPWR VGND sg13g2_fill_2
XFILLER_25_140 VPWR VGND sg13g2_decap_8
XFILLER_72_279 VPWR VGND sg13g2_decap_8
XFILLER_15_74 VPWR VGND sg13g2_fill_1
XFILLER_40_176 VPWR VGND sg13g2_fill_2
XFILLER_36_416 VPWR VGND sg13g2_decap_4
XFILLER_48_265 VPWR VGND sg13g2_fill_2
XFILLER_56_70 VPWR VGND sg13g2_fill_1
XFILLER_51_408 VPWR VGND sg13g2_fill_2
XFILLER_63_268 VPWR VGND sg13g2_decap_4
XFILLER_31_110 VPWR VGND sg13g2_fill_1
XFILLER_32_633 VPWR VGND sg13g2_decap_4
XFILLER_31_121 VPWR VGND sg13g2_fill_1
X_3860_ _3860_/Y _2619_/Y _3889_/B _3858_/X _3859_/Y VPWR VGND sg13g2_a22oi_1
XFILLER_71_290 VPWR VGND sg13g2_fill_2
X_3791_ _3792_/C _3936_/A _4448_/A _3787_/B _4447_/A1 _3786_/X VPWR VGND sg13g2_a221oi_1
X_2811_ _2811_/Y _2811_/A _2811_/B _2811_/C _2811_/D VPWR VGND sg13g2_nand4_1
X_2742_ _3019_/B _2574_/A _5447_/A _3392_/S VPWR VGND sg13g2_mux2_1
X_5461_ _5461_/X _5461_/A VPWR VGND sg13g2_buf_1
X_4412_ _5245_/D _4338_/A hold683/X _4424_/S VPWR VGND sg13g2_mux2_1
X_2673_ _2673_/Y _3000_/B _2673_/B _3000_/C VPWR VGND sg13g2_nand3_1
XFILLER_8_394 VPWR VGND sg13g2_fill_2
X_5392_ _5392_/Q _5392_/CLK _5392_/D _5132_/Y VPWR VGND sg13g2_dfrbpq_1
X_4343_ _5306_/D _3093_/Y hold715/X _4350_/S VPWR VGND sg13g2_mux2_1
Xfanout307 _4095_/B _4096_/B VPWR VGND sg13g2_buf_1
Xfanout318 _3889_/B output130/A VPWR VGND sg13g2_buf_1
Xfanout329 _3847_/A _4464_/A2 VPWR VGND sg13g2_buf_1
X_4274_ _4274_/Y _4353_/A _4276_/B VPWR VGND sg13g2_nand2_1
X_3225_ _3226_/C _3225_/A _3225_/B VPWR VGND sg13g2_nor2_1
XFILLER_67_530 VPWR VGND sg13g2_decap_8
X_3156_ _5431_/D hold837/X _4346_/A _4516_/S VPWR VGND sg13g2_mux2_1
Xclkbuf_leaf_19_clk clkload1/A clkbuf_2_0__f_clk/X VPWR VGND sg13g2_buf_8
X_3087_ _3087_/X _3087_/A _3087_/B VPWR VGND sg13g2_or2_1
XFILLER_54_213 VPWR VGND sg13g2_decap_4
XFILLER_23_600 VPWR VGND sg13g2_fill_1
XFILLER_22_110 VPWR VGND sg13g2_decap_8
XFILLER_50_441 VPWR VGND sg13g2_decap_8
XFILLER_22_198 VPWR VGND sg13g2_fill_2
X_3989_ _3989_/Y _2614_/Y _4059_/A2 _3987_/Y _3988_/Y VPWR VGND sg13g2_a22oi_1
XFILLER_77_58 VPWR VGND sg13g2_decap_8
XFILLER_77_349 VPWR VGND sg13g2_fill_1
XFILLER_26_51 VPWR VGND sg13g2_decap_8
XFILLER_14_611 VPWR VGND sg13g2_decap_8
XFILLER_73_599 VPWR VGND sg13g2_decap_4
XFILLER_60_238 VPWR VGND sg13g2_decap_8
XFILLER_14_644 VPWR VGND sg13g2_decap_8
XFILLER_13_143 VPWR VGND sg13g2_fill_1
XFILLER_41_463 VPWR VGND sg13g2_decap_8
XFILLER_9_114 VPWR VGND sg13g2_decap_8
XFILLER_5_342 VPWR VGND sg13g2_fill_2
XFILLER_54_8 VPWR VGND sg13g2_fill_1
XFILLER_5_397 VPWR VGND sg13g2_decap_8
XFILLER_49_574 VPWR VGND sg13g2_fill_2
X_3010_ _3010_/X _3057_/A _4185_/B _3010_/C _3010_/D VPWR VGND sg13g2_or4_1
XFILLER_76_360 VPWR VGND sg13g2_decap_8
XFILLER_36_213 VPWR VGND sg13g2_fill_1
XFILLER_64_522 VPWR VGND sg13g2_fill_2
XFILLER_17_482 VPWR VGND sg13g2_decap_4
XFILLER_36_279 VPWR VGND sg13g2_fill_1
X_4961_ _4961_/Y _4964_/A VPWR VGND sg13g2_inv_1
XFILLER_64_588 VPWR VGND sg13g2_decap_8
XFILLER_51_249 VPWR VGND sg13g2_decap_8
X_4892_ _4892_/Y _4914_/A _4892_/B _4892_/C VPWR VGND sg13g2_nand3_1
X_3912_ _3927_/A _3916_/B _3910_/Y _3911_/Y VPWR VGND sg13g2_o21ai_1
X_3843_ _3844_/C _4452_/A _3878_/B VPWR VGND sg13g2_nor2_1
X_3774_ _4143_/B _4160_/A _4158_/B VPWR VGND sg13g2_nand2_1
XFILLER_73_0 VPWR VGND sg13g2_decap_8
X_2725_ _2727_/C _5435_/Q _2841_/B _3369_/B1 _5403_/Q VPWR VGND sg13g2_a22oi_1
X_5444_ _5444_/X _5444_/A VPWR VGND sg13g2_buf_1
Xclkbuf_leaf_8_clk _5430_/CLK clkbuf_leaf_9_clk/A VPWR VGND sg13g2_buf_8
X_2656_ _2656_/Y _2656_/A _2656_/B VPWR VGND sg13g2_nand2_1
X_5375_ _5375_/Q clkload7/A _5375_/D _5115_/Y VPWR VGND sg13g2_dfrbpq_1
X_2587_ _2587_/Y _2587_/A VPWR VGND sg13g2_inv_1
X_4326_ _5320_/D _3932_/B hold771/X _4335_/B VPWR VGND sg13g2_mux2_1
X_4257_ _5375_/D hold822/X _4335_/A _4258_/S VPWR VGND sg13g2_mux2_1
XFILLER_59_338 VPWR VGND sg13g2_fill_2
X_4188_ _4188_/Y _4188_/A1 _3375_/Y _3378_/B _4188_/B2 _4187_/Y VPWR VGND sg13g2_a221oi_1
X_3208_ _3208_/Y _4100_/A _3208_/B VPWR VGND sg13g2_nor2_1
XFILLER_27_235 VPWR VGND sg13g2_fill_2
X_3139_ _3139_/Y _3139_/A _3139_/B VPWR VGND sg13g2_xnor2_1
XFILLER_15_408 VPWR VGND sg13g2_decap_8
XFILLER_27_268 VPWR VGND sg13g2_decap_8
XFILLER_42_238 VPWR VGND sg13g2_fill_2
XFILLER_42_249 VPWR VGND sg13g2_decap_8
XFILLER_23_463 VPWR VGND sg13g2_fill_2
XFILLER_10_102 VPWR VGND sg13g2_fill_2
XFILLER_23_485 VPWR VGND sg13g2_decap_8
XFILLER_23_496 VPWR VGND sg13g2_fill_1
XFILLER_50_293 VPWR VGND sg13g2_decap_8
XFILLER_10_146 VPWR VGND sg13g2_decap_4
XFILLER_6_106 VPWR VGND sg13g2_decap_8
XFILLER_2_323 VPWR VGND sg13g2_fill_1
XFILLER_78_614 VPWR VGND sg13g2_fill_2
XFILLER_46_533 VPWR VGND sg13g2_decap_8
XFILLER_58_393 VPWR VGND sg13g2_decap_8
XFILLER_46_544 VPWR VGND sg13g2_fill_1
XFILLER_73_352 VPWR VGND sg13g2_decap_8
XFILLER_61_525 VPWR VGND sg13g2_decap_8
XFILLER_53_82 VPWR VGND sg13g2_decap_8
X_3490_ _3494_/A _5346_/Q _3683_/B1 _3684_/B1 _5282_/Q VPWR VGND sg13g2_a22oi_1
XFILLER_6_651 VPWR VGND sg13g2_fill_1
XFILLER_6_640 VPWR VGND sg13g2_decap_8
X_5160_ _5160_/Y _5160_/A VPWR VGND sg13g2_inv_1
X_5091_ _5091_/Y _5159_/A VPWR VGND sg13g2_inv_1
X_4111_ _4123_/A _4111_/A _4111_/B _4111_/C VPWR VGND sg13g2_nor3_1
XFILLER_69_647 VPWR VGND sg13g2_fill_1
X_4042_ _4043_/C _4450_/C _4092_/B _4450_/B VPWR VGND sg13g2_a21o_1
XFILLER_56_308 VPWR VGND sg13g2_fill_2
XFILLER_37_577 VPWR VGND sg13g2_decap_4
XFILLER_37_599 VPWR VGND sg13g2_decap_8
X_4944_ _4944_/Y _4951_/A VPWR VGND sg13g2_inv_1
X_4875_ _4875_/Y _5219_/Q _4876_/C _4876_/B VPWR VGND sg13g2_a21oi_1
XFILLER_20_444 VPWR VGND sg13g2_decap_8
X_3826_ _3836_/A _4461_/A _3826_/B VPWR VGND sg13g2_nor2_1
XFILLER_20_477 VPWR VGND sg13g2_decap_4
XFILLER_20_499 VPWR VGND sg13g2_fill_2
X_3757_ _3763_/C _4093_/B _3973_/A _4065_/A _3757_/D VPWR VGND sg13g2_nand4_1
X_2708_ _2708_/Y _2708_/A _2708_/B _2708_/C _2708_/D VPWR VGND sg13g2_nand4_1
X_3688_ _3691_/B _5191_/Q _3627_/B _3688_/B1 _5291_/Q VPWR VGND sg13g2_a22oi_1
X_5427_ _5427_/Q _5427_/CLK _5427_/D _5167_/Y VPWR VGND sg13g2_dfrbpq_1
X_2639_ _2640_/B _2682_/B _4521_/B _2637_/Y VPWR VGND sg13g2_a21oi_1
X_5358_ _5358_/Q clkload2/A _5358_/D _5098_/Y VPWR VGND sg13g2_dfrbpq_1
X_4309_ _5335_/D _4346_/A hold836/X _4312_/S VPWR VGND sg13g2_mux2_1
X_5289_ _5289_/Q clkload3/A _5289_/D _5029_/Y VPWR VGND sg13g2_dfrbpq_1
XFILLER_28_544 VPWR VGND sg13g2_decap_8
XFILLER_74_149 VPWR VGND sg13g2_fill_2
XFILLER_55_341 VPWR VGND sg13g2_decap_8
XFILLER_70_311 VPWR VGND sg13g2_decap_8
XFILLER_30_208 VPWR VGND sg13g2_decap_8
XFILLER_70_366 VPWR VGND sg13g2_fill_1
XFILLER_70_355 VPWR VGND sg13g2_decap_8
XFILLER_11_400 VPWR VGND sg13g2_decap_8
XFILLER_11_433 VPWR VGND sg13g2_decap_8
XFILLER_23_282 VPWR VGND sg13g2_decap_8
XFILLER_51_591 VPWR VGND sg13g2_decap_8
XFILLER_23_41 VPWR VGND sg13g2_fill_2
XFILLER_3_0 VPWR VGND sg13g2_decap_8
XFILLER_78_444 VPWR VGND sg13g2_fill_1
XFILLER_78_433 VPWR VGND sg13g2_decap_8
XFILLER_38_319 VPWR VGND sg13g2_decap_8
XFILLER_48_60 VPWR VGND sg13g2_fill_1
XFILLER_48_93 VPWR VGND sg13g2_fill_1
Xfanout490 _4188_/A1 _3210_/A VPWR VGND sg13g2_buf_1
XFILLER_19_566 VPWR VGND sg13g2_fill_1
XFILLER_46_352 VPWR VGND sg13g2_decap_8
XFILLER_0_78 VPWR VGND sg13g2_fill_2
XFILLER_0_89 VPWR VGND sg13g2_decap_4
XFILLER_34_536 VPWR VGND sg13g2_fill_2
X_2990_ _3162_/B _3191_/A _3191_/B VPWR VGND sg13g2_nor2b_1
XFILLER_9_54 VPWR VGND sg13g2_decap_8
XFILLER_61_388 VPWR VGND sg13g2_fill_2
X_4660_ _4661_/B _4660_/A _4660_/B VPWR VGND sg13g2_nand2_1
X_3611_ _3611_/Y _3611_/A _3611_/B _3611_/C _3611_/D VPWR VGND sg13g2_nand4_1
X_4591_ _4591_/Y _4394_/B _4621_/A _5453_/A _4618_/B2 VPWR VGND sg13g2_a22oi_1
X_3542_ _3714_/C _4116_/B _3542_/B _3542_/C VPWR VGND sg13g2_or3_1
X_3473_ _3477_/A _5252_/Q _3685_/B VPWR VGND sg13g2_nand2_1
X_5212_ _5212_/Q _5216_/CLK _5212_/D _4952_/Y VPWR VGND sg13g2_dfrbpq_1
XFILLER_36_0 VPWR VGND sg13g2_decap_8
X_5143_ _5143_/Y _5168_/A VPWR VGND sg13g2_inv_1
XFILLER_69_444 VPWR VGND sg13g2_decap_8
X_5074_ _5074_/Y _5138_/A VPWR VGND sg13g2_inv_1
X_4025_ _4025_/Y _4025_/A _4025_/B _4025_/C VPWR VGND sg13g2_nor3_1
XFILLER_37_363 VPWR VGND sg13g2_decap_8
XFILLER_71_119 VPWR VGND sg13g2_decap_8
XFILLER_25_558 VPWR VGND sg13g2_fill_2
XFILLER_44_18 VPWR VGND sg13g2_fill_1
XFILLER_52_344 VPWR VGND sg13g2_decap_8
XFILLER_12_219 VPWR VGND sg13g2_decap_8
XFILLER_40_528 VPWR VGND sg13g2_decap_8
X_4927_ _4927_/Y _5159_/A VPWR VGND sg13g2_inv_1
X_4858_ _4860_/B _4858_/A _4858_/B VPWR VGND sg13g2_xnor2_1
XFILLER_20_263 VPWR VGND sg13g2_decap_8
X_3809_ _3810_/D _4020_/A _3359_/Y _3807_/Y VPWR VGND sg13g2_o21ai_1
XFILLER_20_296 VPWR VGND sg13g2_decap_8
X_4789_ _4789_/Y _4796_/A _4789_/B VPWR VGND sg13g2_nand2b_1
XFILLER_0_635 VPWR VGND sg13g2_decap_8
XFILLER_48_639 VPWR VGND sg13g2_fill_1
XFILLER_18_41 VPWR VGND sg13g2_fill_2
XFILLER_75_469 VPWR VGND sg13g2_decap_4
XFILLER_18_63 VPWR VGND sg13g2_decap_4
XFILLER_18_85 VPWR VGND sg13g2_fill_2
XFILLER_28_352 VPWR VGND sg13g2_fill_2
XFILLER_62_108 VPWR VGND sg13g2_fill_2
XFILLER_16_558 VPWR VGND sg13g2_fill_2
XFILLER_34_73 VPWR VGND sg13g2_decap_8
XFILLER_43_388 VPWR VGND sg13g2_decap_8
XFILLER_70_196 VPWR VGND sg13g2_decap_8
XFILLER_11_296 VPWR VGND sg13g2_decap_8
XFILLER_50_50 VPWR VGND sg13g2_fill_2
XFILLER_7_256 VPWR VGND sg13g2_decap_8
XFILLER_38_116 VPWR VGND sg13g2_decap_4
XFILLER_39_639 VPWR VGND sg13g2_fill_1
XFILLER_66_436 VPWR VGND sg13g2_decap_8
XFILLER_19_330 VPWR VGND sg13g2_decap_8
XFILLER_75_91 VPWR VGND sg13g2_fill_2
XFILLER_75_80 VPWR VGND sg13g2_fill_2
XFILLER_34_333 VPWR VGND sg13g2_decap_8
XFILLER_74_480 VPWR VGND sg13g2_decap_8
XFILLER_62_642 VPWR VGND sg13g2_fill_1
XFILLER_22_517 VPWR VGND sg13g2_decap_8
X_2973_ _2974_/D _2825_/A _2825_/B _2899_/A _2899_/B VPWR VGND sg13g2_a22oi_1
X_4712_ _4728_/A _4712_/A _4717_/B VPWR VGND sg13g2_xnor2_1
X_4643_ _4643_/Y _5195_/Q _4644_/A VPWR VGND sg13g2_nor2b_1
Xhold702 hold702/X _5365_/Q VPWR VGND sg13g2_dlygate4sd3_1
X_4574_ _4574_/Y _4531_/A _4571_/X _4573_/Y VPWR VGND sg13g2_o21ai_1
Xhold713 hold713/X _5278_/Q VPWR VGND sg13g2_dlygate4sd3_1
Xhold724 hold724/X _5342_/Q VPWR VGND sg13g2_dlygate4sd3_1
Xhold735 hold735/X _5264_/Q VPWR VGND sg13g2_dlygate4sd3_1
Xhold746 hold746/X _5356_/Q VPWR VGND sg13g2_dlygate4sd3_1
X_3525_ _3564_/B _3714_/A _3714_/B VPWR VGND sg13g2_nor2_1
Xhold779 hold779/X _5393_/Q VPWR VGND sg13g2_dlygate4sd3_1
Xhold768 hold768/X _5261_/Q VPWR VGND sg13g2_dlygate4sd3_1
Xhold757 hold757/X _5254_/Q VPWR VGND sg13g2_dlygate4sd3_1
X_3456_ _3460_/A _5183_/Q _3456_/B VPWR VGND sg13g2_nand2_1
X_3387_ _3387_/Y _5278_/Q _3688_/B1 _3555_/B1 _5406_/Q _3386_/Y VPWR VGND sg13g2_a221oi_1
XFILLER_29_105 VPWR VGND sg13g2_decap_4
XFILLER_29_127 VPWR VGND sg13g2_decap_4
X_5126_ _5126_/Y _5158_/A VPWR VGND sg13g2_inv_1
XFILLER_57_436 VPWR VGND sg13g2_decap_4
X_5057_ _5057_/Y _5160_/A VPWR VGND sg13g2_inv_1
X_4008_ _4479_/C _4008_/A _4008_/B _4008_/C _4008_/D VPWR VGND sg13g2_nand4_1
XFILLER_25_322 VPWR VGND sg13g2_fill_2
XFILLER_37_182 VPWR VGND sg13g2_fill_2
XFILLER_65_491 VPWR VGND sg13g2_decap_8
XFILLER_52_174 VPWR VGND sg13g2_fill_1
XFILLER_21_572 VPWR VGND sg13g2_fill_2
XFILLER_20_20 VPWR VGND sg13g2_fill_2
XFILLER_29_40 VPWR VGND sg13g2_decap_8
XFILLER_75_222 VPWR VGND sg13g2_decap_8
XFILLER_29_650 VPWR VGND sg13g2_fill_2
XFILLER_75_288 VPWR VGND sg13g2_decap_8
XFILLER_16_300 VPWR VGND sg13g2_decap_8
XFILLER_28_171 VPWR VGND sg13g2_decap_8
XFILLER_16_344 VPWR VGND sg13g2_decap_8
XFILLER_16_388 VPWR VGND sg13g2_decap_8
XFILLER_31_303 VPWR VGND sg13g2_fill_2
XFILLER_71_472 VPWR VGND sg13g2_decap_8
XFILLER_8_576 VPWR VGND sg13g2_decap_4
XFILLER_6_11 VPWR VGND sg13g2_fill_2
X_3310_ _3315_/B _4068_/A _3289_/B _3847_/A _4440_/B _3309_/Y VPWR VGND sg13g2_a221oi_1
XFILLER_6_77 VPWR VGND sg13g2_fill_2
X_4290_ _5353_/D _3908_/X hold763/X _4294_/S VPWR VGND sg13g2_mux2_1
X_3241_ _3242_/D _3241_/A _3241_/B _3241_/C VPWR VGND sg13g2_nand3_1
X_3172_ _3173_/B _3209_/A1 _3162_/Y _3171_/Y _4074_/A1 VPWR VGND sg13g2_a22oi_1
XFILLER_66_222 VPWR VGND sg13g2_decap_8
XFILLER_81_203 VPWR VGND sg13g2_decap_8
XFILLER_66_255 VPWR VGND sg13g2_decap_8
XFILLER_54_417 VPWR VGND sg13g2_fill_1
XFILLER_35_631 VPWR VGND sg13g2_decap_4
XFILLER_19_193 VPWR VGND sg13g2_decap_4
X_2956_ _2963_/B _4523_/A _2956_/B _2956_/C _2999_/B VPWR VGND sg13g2_nor4_1
XFILLER_30_391 VPWR VGND sg13g2_decap_8
X_2887_ _3313_/B _2887_/A _2887_/B VPWR VGND sg13g2_or2_1
X_4626_ _4627_/B _4630_/C _4626_/B VPWR VGND sg13g2_nand2b_1
X_4557_ _4561_/A _5446_/A _4564_/C VPWR VGND sg13g2_nor2_1
X_4488_ _4488_/Y _5230_/Q _2656_/A _2636_/B VPWR VGND sg13g2_o21ai_1
X_3508_ _3512_/A _5409_/Q _3508_/B VPWR VGND sg13g2_nand2_1
X_3439_ _3440_/B _5382_/Q _3581_/B _3666_/B _5318_/Q VPWR VGND sg13g2_a22oi_1
XFILLER_77_509 VPWR VGND sg13g2_decap_4
XFILLER_66_27 VPWR VGND sg13g2_fill_1
XFILLER_66_16 VPWR VGND sg13g2_decap_8
X_5109_ _5109_/Y _5135_/A VPWR VGND sg13g2_inv_1
XFILLER_45_417 VPWR VGND sg13g2_decap_8
XFILLER_72_236 VPWR VGND sg13g2_fill_2
XFILLER_72_247 VPWR VGND sg13g2_fill_2
XFILLER_41_623 VPWR VGND sg13g2_fill_2
XFILLER_53_472 VPWR VGND sg13g2_fill_1
XFILLER_13_358 VPWR VGND sg13g2_decap_8
XFILLER_25_196 VPWR VGND sg13g2_decap_4
XFILLER_5_535 VPWR VGND sg13g2_fill_1
XFILLER_31_96 VPWR VGND sg13g2_decap_8
XFILLER_68_509 VPWR VGND sg13g2_fill_1
XFILLER_32_612 VPWR VGND sg13g2_fill_2
X_3790_ _3792_/B _3790_/A _3790_/B _3790_/C VPWR VGND sg13g2_nor3_1
X_2810_ _2811_/D _5364_/Q _2927_/A2 _3369_/B1 _5396_/Q VPWR VGND sg13g2_a22oi_1
XFILLER_12_380 VPWR VGND sg13g2_fill_1
X_2741_ _4569_/A _2741_/A _2741_/B _2741_/C _2741_/D VPWR VGND sg13g2_nand4_1
X_5460_ _5460_/X _5460_/A VPWR VGND sg13g2_buf_1
XFILLER_8_373 VPWR VGND sg13g2_decap_8
X_4411_ _5246_/D _4178_/Y hold659/X _4427_/B VPWR VGND sg13g2_mux2_1
X_2672_ _2672_/Y _4489_/B _2956_/B _2999_/B _2999_/C VPWR VGND sg13g2_nor4_1
X_5391_ _5391_/Q _5424_/CLK _5391_/D _5131_/Y VPWR VGND sg13g2_dfrbpq_1
X_4342_ _5307_/D _3068_/Y _4351_/B _4341_/Y VPWR VGND sg13g2_o21ai_1
Xfanout308 _4096_/B _4449_/A VPWR VGND sg13g2_buf_1
Xfanout319 _3953_/A2 output130/A VPWR VGND sg13g2_buf_1
X_4273_ _5364_/D hold754/X _4351_/A _4273_/S VPWR VGND sg13g2_mux2_1
X_3224_ _5428_/D hold827/X _4351_/A _4517_/S VPWR VGND sg13g2_mux2_1
.ends
